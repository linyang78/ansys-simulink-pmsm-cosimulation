# Ansys Electronics Desktop project, version 2026.1
materials:
  Cogent Power - M250-35A, B-H at 50Hz: core_loss_curve{50Hz (0, 0) (0.05, 0.01) (0.1, 0.02) (0.15, 0.04) (0.2, 0.06) (0.25, 0.095) (0.3, 0.13) (0.35, 0.17) (0.4, 0.21) (0.45, 0.26) (0.5, 0.31) (0.55, 0.36) (0.6, 0.41) (0.65, 0.465) (0.7, 0.52) (0.75, 0.59) (0.8, 0.66) (0.85, 0.735) (0.9, 0.81) (0.95, 0.895) (1, 0.98) (1.05, 1.065) (1.1, 1.15) (1.15, 1.26) (1.2, 1.37) (1.25, 1.51) (1.3, 1.65) (1.35, 1.825) (1.4, 2) (1.45, 2.175) (1.5, 2.35) (1.55, 2.5) (1.6, 2.65) (1.65, 2.76) (1.7, 2.87) (1.75, 2.965) (1.8, 3.06)} core_loss_curve{100Hz (0, 0) (0.05, 0.02) (0.1, 0.04) (0.15, 0.09) (0.2, 0.14) (0.25, 0.225) (0.3, 0.31) (0.35, 0.41) (0.4, 0.51) (0.45, 0.63) (0.5, 0.75) (0.55, 0.88) (0.6, 1.01) (0.65, 1.16) (0.7, 1.31) (0.75, 1.475) (0.8, 1.64) (0.85, 1.82) (0.9, 2) (0.95, 2.205) (1, 2.41) (1.05, 2.64) (1.1, 2.87) (1.15, 3.135) (1.2, 3.4) (1.25, 3.715) (1.3, 4.03) (1.35, 4.43) (1.4, 4.83) (1.45, 5.275) (1.5, 5.72) (1.55, 6.165) (1.6, 6.61) (1.65, 7.055) (1.7, 7.5) (1.75, 7.945) (1.8, 8.39)} core_loss_curve{200Hz (0, 0) (0.05, 0.04) (0.1, 0.08) (0.15, 0.205) (0.2, 0.33) (0.25, 0.53) (0.3, 0.73) (0.35, 0.98) (0.4, 1.23) (0.45, 1.525) (0.5, 1.82) (0.55, 2.155) (0.6, 2.49) (0.65, 2.875) (0.7, 3.26) (0.75, 3.69) (0.8, 4.12) (0.85, 4.595) (0.9, 5.07) (0.95, 5.605) (1, 6.14) (1.05, 6.735) (1.1, 7.33) (1.15, 8.01) (1.2, 8.69) (1.25, 9.495) (1.3, 10.3) (1.35, 11.35) (1.4, 12.4) (1.45, 13.55) (1.5, 14.7) (1.55, 15.85) (1.6, 17) (1.65, 18.15) (1.7, 19.3) (1.75, 20.45) (1.8, 21.6)} core_loss_curve{400Hz (0, 0) (0.05, 0.105) (0.1, 0.21) (0.15, 0.555) (0.2, 0.9) (0.25, 1.415) (0.3, 1.93) (0.35, 2.585) (0.4, 3.24) (0.45, 4.025) (0.5, 4.81) (0.55, 5.75) (0.6, 6.69) (0.65, 7.755) (0.7, 8.82) (0.75, 10.01) (0.8, 11.2) (0.85, 12.6) (0.9, 14) (0.95, 15.55) (1, 17.1) (1.05, 18.85) (1.1, 20.6) (1.15, 22.6) (1.2, 24.6) (1.25, 26.9) (1.3, 29.2) (1.35, 32.15) (1.4, 35.1) (1.45, 38.35) (1.5, 41.6) (1.55, 44.85) (1.6, 48.1) (1.65, 51.35) (1.7, 54.6) (1.75, 57.85) (1.8, 61.1)} core_loss_curve{1000Hz (0, 0) (0.05, 0.49) (0.1, 0.98) (0.15, 2.315) (0.2, 3.65) (0.25, 5.615) (0.3, 7.58) (0.35, 10.14) (0.4, 12.7) (0.45, 15.75) (0.5, 18.8) (0.55, 22.55) (0.6, 26.3) (0.65, 30.75) (0.7, 35.2) (0.75, 40.45) (0.8, 45.7) (0.85, 51.9) (0.9, 58.1) (0.95, 65.35) (1, 72.6) (1.05, 81.1) (1.1, 89.6) (1.15, 98.1) (1.2, 106.6) (1.25, 115.1) (1.3, 123.6) (1.35, 132.1) (1.4, 140.6) (1.45, 149.1) (1.5, 157.6) (1.55, 166.1) (1.6, 174.6) (1.65, 183.1) (1.7, 191.6) (1.75, 200.1) (1.8, 208.6)} permeability{HUnit=A_per_meter BUnit=tesla curve (0, 0) (5, 0.00973865) (10, 0.0213622) (15, 0.037698) (20, 0.0578036) (26.8, 0.1) (35.7, 0.2) (41.8, 0.3) (47.5, 0.4) (53.4, 0.5) (60, 0.6) (67.9, 0.7) (77.5, 0.8) (90, 0.9) (107, 1) (133, 1.1) (179, 1.2) (284, 1.3) (642, 1.4) (1810, 1.5) (4030, 1.6) (7290, 1.7) (11700, 1.8) (23345, 1.9396) (46579, 2.0315) (92937, 2.1211) (185430, 2.2531) (369980, 2.4929) (738210, 2.9596)} conductivity=1818180 core_loss_type="Electrical Steel" core_loss_kh=154.002 core_loss_kc=0.211517 core_loss_ke=6.20168 mass_density=7650
  SmCo28: permittivity=1 permeability=1.038389 conductivity=1111111 magnetic_coercivity{Magnitude=-820000A_per_meter DirComp1=1 DirComp2=0 DirComp3=0} lande_g_factor=2
  copper: permeability=0.999991 conductivity=58000000
  vacuum: permittivity=1
  Al-Extruded
  air: permittivity=1.0006 permeability=1.0000004
surface materials:
  Steel-oxidised-surface

design Original Secondary-36 (Maxwell 2D, Transient, XY geometry, model units mm)
options: ComputeTransientInductance ModelDepth=90mm
variables:
  A = 0A
  f = 150Hz
  N = 30
  h = 20mm
  RL = (38.5-1000*h) mm
geometry:
  N = circle(normal=Z, centre=(0mm, 0mm, 0mm), radius=38.5mm)
  Circle8 = circle(normal=Z, centre=(0mm, 0mm, 0mm), radius=33.5mm)
  N.subtract(Circle8)
  Polyline1 = polyline((0mm, 0mm, 0mm) (48.296291mm, 12.940952mm, 0mm))
  Polyline1_1 = Polyline1.duplicate_around_axis(axis=Z, angle=-30deg, total=2)
  Polyline2 = polyline((48.296291mm, 12.940952mm, 0mm) (48.296291mm, -12.940952mm, 0mm))
  Polyline1.unite(Polyline1_1, Polyline2)
  Polyline1.cover_lines()
  N.intersect(Polyline1)
  Polyline3 = polyline(z=0mm, xy in mm: (32.358515, 8.670438) (33.5, 1.7763568e-15) (32.358515, -8.670438), AngularArc from point 0 over 3 centre=(0mm, 0mm, 0mm) angle=-30deg plane=XY)
  Polyline4 = polyline((32.358515mm, 8.670438mm, 0mm) (32.358515mm, -8.670438mm, 0mm))
  Polyline3.unite(Polyline4)
  Polyline3.cover_lines()
  N.unite(Polyline3)
  Rectangle1 = rectangle(corner=(32.358515mm, 8.670438mm, 0mm), x_size=5.6414848mm, y_size=2.329562mm)
  Rectangle1_1 = Rectangle1.duplicate_mirror(point=(0mm, 0mm, 0mm), normal=(0mm, -1mm, 0mm))
  N.subtract(Rectangle1, Rectangle1_1)
  Stator [Cogent Power - M250-35A, B-H at 50Hz] = user_primitive(RMxprt/SlotCore.dll, DiaGap=80mm, DiaYoke=125mm, Length=0mm, Skew=0deg, Slots=36, SlotType=3, Hs0=0.5mm, Hs01=0mm, Hs1=0.5mm, Hs2=13.5mm, Bs0=2mm, Bs1=4mm, Bs2=6mm, Rs=0mm, FilletType=0, HalfSlot=0, SegAngle=15deg, LenRegion=200mm, InfoCore=0)
  Rectangle2 = rectangle(corner=(32.358515mm, 8.670438mm, 0mm), x_size=5.6414848mm, y_size=-0.6mm)
  Rectangle2_1 = Rectangle2.duplicate_mirror(point=(0mm, 0mm, 0mm), normal=(0mm, -1mm, 0mm))
  N.subtract(Rectangle2, Rectangle2_1)
  Rectangle3 = rectangle(corner=(33.5mm, 0mm, 0mm), x_size=5.5mm, y_size=8mm)
  Rectangle3_1 = Rectangle3.duplicate_mirror(point=(0mm, 0mm, 0mm), normal=(0mm, -1mm, 0mm))
  Rectangle3.unite(Rectangle3_1)
  N.intersect(Rectangle3)
  S = N.duplicate_around_axis(axis=Z, angle=30deg, total=2)
  S_1..S_5 = S.duplicate_around_axis(axis=Z, angle=60deg, total=6)
  N_1..N_5 = N.duplicate_around_axis(axis=Z, angle=60deg, total=6)
  N_6 = N.copy()
  N_6.delete()
  N_1_1 = N_1.copy()
  N_1_1.delete()
  N_2_1 = N_2.copy()
  N_2_1.delete()
  N_3_1 = N_3.copy()
  N_3_1.delete()
  N_4_1 = N_4.copy()
  N_4_1.delete()
  N_5_1 = N_5.copy()
  N_5_1.delete()
  S_6 = S.copy()
  S_6.delete()
  S_1_1 = S_1.copy()
  S_1_1.delete()
  S_2_1 = S_2.copy()
  S_2_1.delete()
  S_3_1 = S_3.copy()
  S_3_1.delete()
  S_4_1 = S_4.copy()
  S_4_1.delete()
  S_5_1 = S_5.copy()
  S_5_1.delete()
  coordinate_system FaceCS1 = face of N: Origin=(33.5, 0, 0) FaceID=N.face(#59) AxisPosn=(38.5, 0, 0) WhichAxis=X ZRotationAngle=0deg XOffset=0mm YOffset=0mm FaceNormal(0, 0, 1)
  S.delete()
  coordinate_system FaceCS2 = face of S: Origin=(33.341978, 19.25, 0) FaceID=?.face(#9965) AxisPosn=(29.011851, 16.75, 0) WhichAxis=X ZRotationAngle=0deg XOffset=0mm YOffset=0mm FaceNormal(0, 0, 1)
  N_1.delete()
  coordinate_system FaceCS3 = face of N_1: Origin=(16.75, 29.011851, 0) FaceID=?.face(#10033) AxisPosn=(19.25, 33.341978, 0) WhichAxis=X ZRotationAngle=0deg XOffset=0mm YOffset=0mm FaceNormal(0, 0, 1)
  S_1.delete()
  coordinate_system FaceCS4 = face of S_1: Origin=(0, 38.5, 0) FaceID=?.face(#9977) AxisPosn=(0, 33.5, 0) WhichAxis=X ZRotationAngle=0deg XOffset=0mm YOffset=0mm FaceNormal(0, 0, 1)
  N_2.delete()
  coordinate_system FaceCS5 = face of N_2: Origin=(-16.75, 29.011851, 0) FaceID=?.face(#10044) AxisPosn=(-19.25, 33.341978, 0) WhichAxis=X ZRotationAngle=0deg XOffset=0mm YOffset=0mm FaceNormal(0, 0, 1)
  S_2.delete()
  coordinate_system FaceCS6 = face of S_2: Origin=(-33.341978, 19.25, 0) FaceID=?.face(#9988) AxisPosn=(-29.011851, 16.75, 0) WhichAxis=X ZRotationAngle=0deg XOffset=0mm YOffset=0mm FaceNormal(0, 0, 1)
  N_3.delete()
  coordinate_system FaceCS7 = face of N_3: Origin=(-33.5, 0, 0) FaceID=?.face(#10055) AxisPosn=(-38.5, 0, 0) WhichAxis=X ZRotationAngle=0deg XOffset=0mm YOffset=0mm FaceNormal(0, 0, 1)
  S_3.delete()
  coordinate_system FaceCS8 = face of S_3: Origin=(-33.341978, -19.25, 0) FaceID=?.face(#9999) AxisPosn=(-29.011851, -16.75, 0) WhichAxis=X ZRotationAngle=0deg XOffset=0mm YOffset=0mm FaceNormal(0, 0, 1)
  N_4.delete()
  coordinate_system FaceCS9 = face of N_4: Origin=(-16.75, -29.011851, 0) FaceID=?.face(#10066) AxisPosn=(-19.25, -33.341978, 0) WhichAxis=X ZRotationAngle=0deg XOffset=0mm YOffset=0mm FaceNormal(0, 0, 1)
  S_4.delete()
  coordinate_system FaceCS10 = face of S_4: Origin=(0, -38.5, 0) FaceID=?.face(#10010) AxisPosn=(0, -33.5, 0) WhichAxis=X ZRotationAngle=0deg XOffset=0mm YOffset=0mm FaceNormal(0, 0, 1)
  N_5.delete()
  coordinate_system FaceCS11 = face of N_5: Origin=(16.75, -29.011851, 0) FaceID=?.face(#10077) AxisPosn=(19.25, -33.341978, 0) WhichAxis=X ZRotationAngle=0deg XOffset=0mm YOffset=0mm FaceNormal(0, 0, 1)
  S_5.delete()
  coordinate_system FaceCS12 = face of S_5: Origin=(33.341978, -19.25, 0) FaceID=?.face(#10021) AxisPosn=(29.011851, -16.75, 0) WhichAxis=X ZRotationAngle=0deg XOffset=0mm YOffset=0mm FaceNormal(0, 0, 1)
  A [copper] = rectangle(corner=(41.4mm, 1.8mm, 0mm), x_size=12.8mm, y_size=-1.9mm)
  Rectangle4_1 = A.duplicate_mirror(point=(39mm, 0mm, 0mm), normal=(0mm, -1mm, 0mm))
  A.unite(Rectangle4_1)
  A.rotate(axis=Z, angle=5deg)
  Z, B, X, C, Y [copper] = A.duplicate_around_axis(axis=Z, angle=10deg, total=6)
  A_1..A_5 [copper] = A.duplicate_around_axis(axis=Z, angle=60deg, total=6)
  Z_1..Z_5 [copper] = Z.duplicate_around_axis(axis=Z, angle=60deg, total=6)
  B_1..B_5 [copper] = B.duplicate_around_axis(axis=Z, angle=60deg, total=6)
  X_1..X_5 [copper] = X.duplicate_around_axis(axis=Z, angle=60deg, total=6)
  C_1..C_5 [copper] = C.duplicate_around_axis(axis=Z, angle=60deg, total=6)
  Y_1..Y_5 [copper] = Y.duplicate_around_axis(axis=Z, angle=60deg, total=6)
  Band [vacuum] = circle(normal=Z, centre=(0mm, 0mm, 0mm), radius=39.25mm)
  Region [vacuum] = circle(normal=Z, centre=(0mm, 0mm, 0mm), radius=70mm)
  N_8 [SmCo28, oriented by FaceCS1] = circle(normal=Z, centre=(h, 0mm, 0mm), radius=RL)
  N_8.intersect(N)
  N_7_1 [SmCo28, oriented by FaceCS3], N_7_2 [SmCo28, oriented by FaceCS5], N_7_3 [SmCo28, oriented by FaceCS7], N_7_4 [SmCo28, oriented by FaceCS9], N_7_5 [SmCo28, oriented by FaceCS11] = N_8.duplicate_around_axis(axis=Z, angle=60deg, total=6)
  S_7 [SmCo28, oriented by FaceCS2] = N_8.duplicate_around_axis(axis=Z, angle=30deg, total=2)
  S_7_1 [SmCo28, oriented by FaceCS4], S_7_2 [SmCo28, oriented by FaceCS6], S_7_3 [SmCo28, oriented by FaceCS8], S_7_4 [SmCo28, oriented by FaceCS10], S_7_5 [SmCo28, oriented by FaceCS12] = S_7.duplicate_around_axis(axis=Z, angle=60deg, total=6)
  [N_8, N_7_1..N_7_5, S_7, S_7_1..S_7_5].rotate(axis=Z, angle=20.289deg)
  [N_8, N_7_1..N_7_5, S_7, S_7_1..S_7_5].rotate(axis=Z, angle=1.23deg)
  N_8.rotate(axis=Z, angle=-0.03deg)
  N_7_1.rotate(axis=Z, angle=-0.03deg)
  N_7_2.rotate(axis=Z, angle=-0.03deg)
  N_7_3.rotate(axis=Z, angle=-0.03deg)
  N_7_4.rotate(axis=Z, angle=-0.03deg)
  N_7_5.rotate(axis=Z, angle=-0.03deg)
  S_7.rotate(axis=Z, angle=-0.03deg)
  S_7_1.rotate(axis=Z, angle=-0.03deg)
  S_7_2.rotate(axis=Z, angle=-0.03deg)
  S_7_3.rotate(axis=Z, angle=-0.03deg)
  S_7_4.rotate(axis=Z, angle=-0.03deg)
  S_7_5.rotate(axis=Z, angle=-0.03deg)
  [N_8, N_7_1..N_7_5, S_7, S_7_1..S_7_5].rotate(axis=Z, angle=-0.03deg)
  [N_8, N_7_1..N_7_5, S_7, S_7_1..S_7_5].rotate(axis=Z, angle=0.1deg)
  [N_8, N_7_1..N_7_5, S_7, S_7_1..S_7_5].rotate(axis=Z, angle=0.03deg)
  Rotor [Cogent Power - M250-35A, B-H at 50Hz] = imported_body()
motion:
  MotionSetup1: Band Move_Type=Rotate Coordinate_System=Global Axis=Z Is_Positive=true InitPos=0deg Angular_Velocity=1500rpm Objects=Band
  Moving1: Moving Objects=[Rotor, N_8, N_7_1..N_7_5, S_7, S_7_1..S_7_5]
boundaries and excitations:
  VectorPotential1: Vector Potential Edges=Region.edge(at (-70, 0, 0)) Value=0
  A: Coil Objects=A Conductor_number=N Winding=WindingA PolarityType=Positive
  A_1: Coil Objects=A_1 Conductor_number=N Winding=WindingA PolarityType=Positive
  A_2: Coil Objects=A_2 Conductor_number=N Winding=WindingA PolarityType=Positive
  A_3: Coil Objects=A_3 Conductor_number=N Winding=WindingA PolarityType=Positive
  A_4: Coil Objects=A_4 Conductor_number=N Winding=WindingA PolarityType=Positive
  A_5: Coil Objects=A_5 Conductor_number=N Winding=WindingA PolarityType=Positive
  B: Coil Objects=B Conductor_number=N Winding=WindingB PolarityType=Positive
  B_1: Coil Objects=B_1 Conductor_number=N Winding=WindingB PolarityType=Positive
  B_2: Coil Objects=B_2 Conductor_number=N Winding=WindingB PolarityType=Positive
  B_3: Coil Objects=B_3 Conductor_number=N Winding=WindingB PolarityType=Positive
  B_4: Coil Objects=B_4 Conductor_number=N Winding=WindingB PolarityType=Positive
  B_5: Coil Objects=B_5 Conductor_number=N Winding=WindingB PolarityType=Positive
  C: Coil Objects=C Conductor_number=N Winding=WindingC PolarityType=Positive
  C_1: Coil Objects=C_1 Conductor_number=N Winding=WindingC PolarityType=Positive
  C_2: Coil Objects=C_2 Conductor_number=N Winding=WindingC PolarityType=Positive
  C_3: Coil Objects=C_3 Conductor_number=N Winding=WindingC PolarityType=Positive
  C_4: Coil Objects=C_4 Conductor_number=N Winding=WindingC PolarityType=Positive
  C_5: Coil Objects=C_5 Conductor_number=N Winding=WindingC PolarityType=Positive
  X: Coil Objects=X Conductor_number=N Winding=WindingA PolarityType=Negative
  X_1: Coil Objects=X_1 Conductor_number=N Winding=WindingA PolarityType=Negative
  X_2: Coil Objects=X_2 Conductor_number=N Winding=WindingA PolarityType=Negative
  X_3: Coil Objects=X_3 Conductor_number=N Winding=WindingA PolarityType=Negative
  X_4: Coil Objects=X_4 Conductor_number=N Winding=WindingA PolarityType=Negative
  X_5: Coil Objects=X_5 Conductor_number=N Winding=WindingA PolarityType=Negative
  Y: Coil Objects=Y Conductor_number=N Winding=WindingB PolarityType=Negative
  Y_1: Coil Objects=Y_1 Conductor_number=N Winding=WindingB PolarityType=Negative
  Y_2: Coil Objects=Y_2 Conductor_number=N Winding=WindingB PolarityType=Negative
  Y_3: Coil Objects=Y_3 Conductor_number=N Winding=WindingB PolarityType=Negative
  Y_4: Coil Objects=Y_4 Conductor_number=N Winding=WindingB PolarityType=Negative
  Y_5: Coil Objects=Y_5 Conductor_number=N Winding=WindingB PolarityType=Negative
  Z: Coil Objects=Z Conductor_number=N Winding=WindingC PolarityType=Negative
  Z_1: Coil Objects=Z_1 Conductor_number=N Winding=WindingC PolarityType=Negative
  Z_2: Coil Objects=Z_2 Conductor_number=N Winding=WindingC PolarityType=Negative
  Z_3: Coil Objects=Z_3 Conductor_number=N Winding=WindingC PolarityType=Negative
  Z_4: Coil Objects=Z_4 Conductor_number=N Winding=WindingC PolarityType=Negative
  Z_5: Coil Objects=Z_5 Conductor_number=N Winding=WindingC PolarityType=Negative
  WindingA: Winding Group Type=Current IsSolid=false Current=A*sin(2*pi*f*time) ParallelBranchesNum=1
  WindingB: Winding Group Type=Current IsSolid=false Current=A*sin(2*pi*f*time-2*pi/3) ParallelBranchesNum=1
  WindingC: Winding Group Type=Current IsSolid=false Current=A*sin(2*pi*f*time+2*pi/3) ParallelBranchesNum=1
mesh:
  CylindricalGap1: CylindricalGap Objects=Band Objects=Band
  Region: LengthBased RefineInside Objects=Region MaxLength=8mm
  SR: LengthBased RefineInside Objects=[Stator, Rotor] MaxLength=4mm
  Band: LengthBased Objects=Band MaxLength=0.5mm
setups:
  Setup1: Transient NonlinearSolverResidual=0.0001 ScalarPotential="Second Order" StopTime="(1/150) s" TimeStep="(1/150/50) s" InitialTimeStep=0.002s MinTimeStep=0.001s MaxTimeStep=0.003s TimeStepErrTolerance=0.0001
field calculator expressions:
  Br = Fundamental_Quantity(22) | 2D_Normal | Dot
  Bt = Fundamental_Quantity(22) | Tangent | Dot
field plots:
  Mesh1: MeshPlots over Rotor, Stator, A, Z, B, X, C, Y, A_1..A_5, Z_1..Z_5, B_1..B_5, X_1..X_5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 on Setup1 : Transient at Time=-1
  Flux_Lines1: A over Stator, Rotor, N_7_1..N_7_5, N_8, S_7, S_7_1..S_7_5 on Setup1 : Transient at Time=-1
  Mag_B1: B over Stator, Rotor, N_7_1..N_7_5, N_8, S_7, S_7_1..S_7_5 on Setup1 : Transient at Time=-1
reports:
  Winding Plot 1: FluxLinkage(WindingA), FluxLinkage(WindingB), FluxLinkage(WindingC) vs Time on Setup1 : Transient
  Winding Plot 2: InducedVoltage(WindingA), InducedVoltage(WindingB), InducedVoltage(WindingC) vs Time on Setup1 : Transient; markers MY1 at y=0
  Plot 1: L(d - axis), L(q - axis) vs Time on Setup1 : Transient
  Torque Plot 1: Moving1.Torque vs Time on Setup1 : Transient [A=all]

design ECE (Maxwell 2D, Transient, XY geometry, model units mm)
options: ComputeTransientInductance ModelDepth=90mm
variables:
  A = 0A
  f = 150Hz
  N = 30
  h = 20mm
  RL = (38.5-1000*h) mm
geometry:
  N = circle(normal=Z, centre=(0mm, 0mm, 0mm), radius=38.5mm)
  Circle8 = circle(normal=Z, centre=(0mm, 0mm, 0mm), radius=33.5mm)
  N.subtract(Circle8)
  Polyline1 = polyline((0mm, 0mm, 0mm) (48.296291mm, 12.940952mm, 0mm))
  Polyline1_1 = Polyline1.duplicate_around_axis(axis=Z, angle=-30deg, total=2)
  Polyline2 = polyline((48.296291mm, 12.940952mm, 0mm) (48.296291mm, -12.940952mm, 0mm))
  Polyline1.unite(Polyline1_1, Polyline2)
  Polyline1.cover_lines()
  N.intersect(Polyline1)
  Polyline3 = polyline(z=0mm, xy in mm: (32.358515, 8.670438) (33.5, 1.7763568e-15) (32.358515, -8.670438), AngularArc from point 0 over 3 centre=(0mm, 0mm, 0mm) angle=-30deg plane=XY)
  Polyline4 = polyline((32.358515mm, 8.670438mm, 0mm) (32.358515mm, -8.670438mm, 0mm))
  Polyline3.unite(Polyline4)
  Polyline3.cover_lines()
  N.unite(Polyline3)
  Rectangle1 = rectangle(corner=(32.358515mm, 8.670438mm, 0mm), x_size=5.6414848mm, y_size=2.329562mm)
  Rectangle1_1 = Rectangle1.duplicate_mirror(point=(0mm, 0mm, 0mm), normal=(0mm, -1mm, 0mm))
  N.subtract(Rectangle1, Rectangle1_1)
  Stator [Cogent Power - M250-35A, B-H at 50Hz] = user_primitive(RMxprt/SlotCore.dll, DiaGap=80mm, DiaYoke=125mm, Length=0mm, Skew=0deg, Slots=36, SlotType=3, Hs0=0.5mm, Hs01=0mm, Hs1=0.5mm, Hs2=13.5mm, Bs0=2mm, Bs1=4mm, Bs2=6mm, Rs=0mm, FilletType=0, HalfSlot=0, SegAngle=15deg, LenRegion=200mm, InfoCore=0)
  Rectangle2 = rectangle(corner=(32.358515mm, 8.670438mm, 0mm), x_size=5.6414848mm, y_size=-0.6mm)
  Rectangle2_1 = Rectangle2.duplicate_mirror(point=(0mm, 0mm, 0mm), normal=(0mm, -1mm, 0mm))
  N.subtract(Rectangle2, Rectangle2_1)
  Rectangle3 = rectangle(corner=(33.5mm, 0mm, 0mm), x_size=5.5mm, y_size=8mm)
  Rectangle3_1 = Rectangle3.duplicate_mirror(point=(0mm, 0mm, 0mm), normal=(0mm, -1mm, 0mm))
  Rectangle3.unite(Rectangle3_1)
  N.intersect(Rectangle3)
  S = N.duplicate_around_axis(axis=Z, angle=30deg, total=2)
  S_1..S_5 = S.duplicate_around_axis(axis=Z, angle=60deg, total=6)
  N_1..N_5 = N.duplicate_around_axis(axis=Z, angle=60deg, total=6)
  N_6 = N.copy()
  N_6.delete()
  N_1_1 = N_1.copy()
  N_1_1.delete()
  N_2_1 = N_2.copy()
  N_2_1.delete()
  N_3_1 = N_3.copy()
  N_3_1.delete()
  N_4_1 = N_4.copy()
  N_4_1.delete()
  N_5_1 = N_5.copy()
  N_5_1.delete()
  S_6 = S.copy()
  S_6.delete()
  S_1_1 = S_1.copy()
  S_1_1.delete()
  S_2_1 = S_2.copy()
  S_2_1.delete()
  S_3_1 = S_3.copy()
  S_3_1.delete()
  S_4_1 = S_4.copy()
  S_4_1.delete()
  S_5_1 = S_5.copy()
  S_5_1.delete()
  coordinate_system FaceCS1 = face of N: Origin=(33.5, 0, 0) FaceID=N.face(#59) AxisPosn=(38.5, 0, 0) WhichAxis=X ZRotationAngle=0deg XOffset=0mm YOffset=0mm FaceNormal(0, 0, 1)
  S.delete()
  coordinate_system FaceCS2 = face of S: Origin=(33.341978, 19.25, 0) FaceID=?.face(#9965) AxisPosn=(29.011851, 16.75, 0) WhichAxis=X ZRotationAngle=0deg XOffset=0mm YOffset=0mm FaceNormal(0, 0, 1)
  N_1.delete()
  coordinate_system FaceCS3 = face of N_1: Origin=(16.75, 29.011851, 0) FaceID=?.face(#10033) AxisPosn=(19.25, 33.341978, 0) WhichAxis=X ZRotationAngle=0deg XOffset=0mm YOffset=0mm FaceNormal(0, 0, 1)
  S_1.delete()
  coordinate_system FaceCS4 = face of S_1: Origin=(0, 38.5, 0) FaceID=?.face(#9977) AxisPosn=(0, 33.5, 0) WhichAxis=X ZRotationAngle=0deg XOffset=0mm YOffset=0mm FaceNormal(0, 0, 1)
  N_2.delete()
  coordinate_system FaceCS5 = face of N_2: Origin=(-16.75, 29.011851, 0) FaceID=?.face(#10044) AxisPosn=(-19.25, 33.341978, 0) WhichAxis=X ZRotationAngle=0deg XOffset=0mm YOffset=0mm FaceNormal(0, 0, 1)
  S_2.delete()
  coordinate_system FaceCS6 = face of S_2: Origin=(-33.341978, 19.25, 0) FaceID=?.face(#9988) AxisPosn=(-29.011851, 16.75, 0) WhichAxis=X ZRotationAngle=0deg XOffset=0mm YOffset=0mm FaceNormal(0, 0, 1)
  N_3.delete()
  coordinate_system FaceCS7 = face of N_3: Origin=(-33.5, 0, 0) FaceID=?.face(#10055) AxisPosn=(-38.5, 0, 0) WhichAxis=X ZRotationAngle=0deg XOffset=0mm YOffset=0mm FaceNormal(0, 0, 1)
  S_3.delete()
  coordinate_system FaceCS8 = face of S_3: Origin=(-33.341978, -19.25, 0) FaceID=?.face(#9999) AxisPosn=(-29.011851, -16.75, 0) WhichAxis=X ZRotationAngle=0deg XOffset=0mm YOffset=0mm FaceNormal(0, 0, 1)
  N_4.delete()
  coordinate_system FaceCS9 = face of N_4: Origin=(-16.75, -29.011851, 0) FaceID=?.face(#10066) AxisPosn=(-19.25, -33.341978, 0) WhichAxis=X ZRotationAngle=0deg XOffset=0mm YOffset=0mm FaceNormal(0, 0, 1)
  S_4.delete()
  coordinate_system FaceCS10 = face of S_4: Origin=(0, -38.5, 0) FaceID=?.face(#10010) AxisPosn=(0, -33.5, 0) WhichAxis=X ZRotationAngle=0deg XOffset=0mm YOffset=0mm FaceNormal(0, 0, 1)
  N_5.delete()
  coordinate_system FaceCS11 = face of N_5: Origin=(16.75, -29.011851, 0) FaceID=?.face(#10077) AxisPosn=(19.25, -33.341978, 0) WhichAxis=X ZRotationAngle=0deg XOffset=0mm YOffset=0mm FaceNormal(0, 0, 1)
  S_5.delete()
  coordinate_system FaceCS12 = face of S_5: Origin=(33.341978, -19.25, 0) FaceID=?.face(#10021) AxisPosn=(29.011851, -16.75, 0) WhichAxis=X ZRotationAngle=0deg XOffset=0mm YOffset=0mm FaceNormal(0, 0, 1)
  A [copper] = rectangle(corner=(41.4mm, 1.8mm, 0mm), x_size=12.8mm, y_size=-1.9mm)
  Rectangle4_1 = A.duplicate_mirror(point=(39mm, 0mm, 0mm), normal=(0mm, -1mm, 0mm))
  A.unite(Rectangle4_1)
  A.rotate(axis=Z, angle=5deg)
  Z, B, X, C, Y [copper] = A.duplicate_around_axis(axis=Z, angle=10deg, total=6)
  A_1..A_5 [copper] = A.duplicate_around_axis(axis=Z, angle=60deg, total=6)
  Z_1..Z_5 [copper] = Z.duplicate_around_axis(axis=Z, angle=60deg, total=6)
  B_1..B_5 [copper] = B.duplicate_around_axis(axis=Z, angle=60deg, total=6)
  X_1..X_5 [copper] = X.duplicate_around_axis(axis=Z, angle=60deg, total=6)
  C_1..C_5 [copper] = C.duplicate_around_axis(axis=Z, angle=60deg, total=6)
  Y_1..Y_5 [copper] = Y.duplicate_around_axis(axis=Z, angle=60deg, total=6)
  Band [vacuum] = circle(normal=Z, centre=(0mm, 0mm, 0mm), radius=39.25mm)
  Region [vacuum] = circle(normal=Z, centre=(0mm, 0mm, 0mm), radius=70mm)
  N_8 [SmCo28, oriented by FaceCS1] = circle(normal=Z, centre=(h, 0mm, 0mm), radius=RL)
  N_8.intersect(N)
  N_7_1 [SmCo28, oriented by FaceCS3], N_7_2 [SmCo28, oriented by FaceCS5], N_7_3 [SmCo28, oriented by FaceCS7], N_7_4 [SmCo28, oriented by FaceCS9], N_7_5 [SmCo28, oriented by FaceCS11] = N_8.duplicate_around_axis(axis=Z, angle=60deg, total=6)
  S_7 [SmCo28, oriented by FaceCS2] = N_8.duplicate_around_axis(axis=Z, angle=30deg, total=2)
  S_7_1 [SmCo28, oriented by FaceCS4], S_7_2 [SmCo28, oriented by FaceCS6], S_7_3 [SmCo28, oriented by FaceCS8], S_7_4 [SmCo28, oriented by FaceCS10], S_7_5 [SmCo28, oriented by FaceCS12] = S_7.duplicate_around_axis(axis=Z, angle=60deg, total=6)
  [N_8, N_7_1..N_7_5, S_7, S_7_1..S_7_5].rotate(axis=Z, angle=20.289deg)
  [N_8, N_7_1..N_7_5, S_7, S_7_1..S_7_5].rotate(axis=Z, angle=1.23deg)
  N_8.rotate(axis=Z, angle=-0.03deg)
  N_7_1.rotate(axis=Z, angle=-0.03deg)
  N_7_2.rotate(axis=Z, angle=-0.03deg)
  N_7_3.rotate(axis=Z, angle=-0.03deg)
  N_7_4.rotate(axis=Z, angle=-0.03deg)
  N_7_5.rotate(axis=Z, angle=-0.03deg)
  S_7.rotate(axis=Z, angle=-0.03deg)
  S_7_1.rotate(axis=Z, angle=-0.03deg)
  S_7_2.rotate(axis=Z, angle=-0.03deg)
  S_7_3.rotate(axis=Z, angle=-0.03deg)
  S_7_4.rotate(axis=Z, angle=-0.03deg)
  S_7_5.rotate(axis=Z, angle=-0.03deg)
  [N_8, N_7_1..N_7_5, S_7, S_7_1..S_7_5].rotate(axis=Z, angle=-0.03deg)
  [N_8, N_7_1..N_7_5, S_7, S_7_1..S_7_5].rotate(axis=Z, angle=0.1deg)
  [N_8, N_7_1..N_7_5, S_7, S_7_1..S_7_5].rotate(axis=Z, angle=0.03deg)
motion:
  MotionSetup1: Band Move_Type=Rotate Coordinate_System=Global Axis=Z Is_Positive=true InitPos=0deg Angular_Velocity=1500rpm Objects=Band
  Moving1: Moving Objects=[#41, N_8, N_7_1..N_7_5, S_7, S_7_1..S_7_5]
boundaries and excitations:
  VectorPotential1: Vector Potential Edges=Region.edge(at (-70, 0, 0)) Value=0
  A: Coil Objects=A Conductor_number=N Winding=WindingA PolarityType=Positive
  A_1: Coil Objects=A_1 Conductor_number=N Winding=WindingA PolarityType=Positive
  A_2: Coil Objects=A_2 Conductor_number=N Winding=WindingA PolarityType=Positive
  A_3: Coil Objects=A_3 Conductor_number=N Winding=WindingA PolarityType=Positive
  A_4: Coil Objects=A_4 Conductor_number=N Winding=WindingA PolarityType=Positive
  A_5: Coil Objects=A_5 Conductor_number=N Winding=WindingA PolarityType=Positive
  B: Coil Objects=B Conductor_number=N Winding=WindingB PolarityType=Positive
  B_1: Coil Objects=B_1 Conductor_number=N Winding=WindingB PolarityType=Positive
  B_2: Coil Objects=B_2 Conductor_number=N Winding=WindingB PolarityType=Positive
  B_3: Coil Objects=B_3 Conductor_number=N Winding=WindingB PolarityType=Positive
  B_4: Coil Objects=B_4 Conductor_number=N Winding=WindingB PolarityType=Positive
  B_5: Coil Objects=B_5 Conductor_number=N Winding=WindingB PolarityType=Positive
  C: Coil Objects=C Conductor_number=N Winding=WindingC PolarityType=Positive
  C_1: Coil Objects=C_1 Conductor_number=N Winding=WindingC PolarityType=Positive
  C_2: Coil Objects=C_2 Conductor_number=N Winding=WindingC PolarityType=Positive
  C_3: Coil Objects=C_3 Conductor_number=N Winding=WindingC PolarityType=Positive
  C_4: Coil Objects=C_4 Conductor_number=N Winding=WindingC PolarityType=Positive
  C_5: Coil Objects=C_5 Conductor_number=N Winding=WindingC PolarityType=Positive
  X: Coil Objects=X Conductor_number=N Winding=WindingA PolarityType=Negative
  X_1: Coil Objects=X_1 Conductor_number=N Winding=WindingA PolarityType=Negative
  X_2: Coil Objects=X_2 Conductor_number=N Winding=WindingA PolarityType=Negative
  X_3: Coil Objects=X_3 Conductor_number=N Winding=WindingA PolarityType=Negative
  X_4: Coil Objects=X_4 Conductor_number=N Winding=WindingA PolarityType=Negative
  X_5: Coil Objects=X_5 Conductor_number=N Winding=WindingA PolarityType=Negative
  Y: Coil Objects=Y Conductor_number=N Winding=WindingB PolarityType=Negative
  Y_1: Coil Objects=Y_1 Conductor_number=N Winding=WindingB PolarityType=Negative
  Y_2: Coil Objects=Y_2 Conductor_number=N Winding=WindingB PolarityType=Negative
  Y_3: Coil Objects=Y_3 Conductor_number=N Winding=WindingB PolarityType=Negative
  Y_4: Coil Objects=Y_4 Conductor_number=N Winding=WindingB PolarityType=Negative
  Y_5: Coil Objects=Y_5 Conductor_number=N Winding=WindingB PolarityType=Negative
  Z: Coil Objects=Z Conductor_number=N Winding=WindingC PolarityType=Negative
  Z_1: Coil Objects=Z_1 Conductor_number=N Winding=WindingC PolarityType=Negative
  Z_2: Coil Objects=Z_2 Conductor_number=N Winding=WindingC PolarityType=Negative
  Z_3: Coil Objects=Z_3 Conductor_number=N Winding=WindingC PolarityType=Negative
  Z_4: Coil Objects=Z_4 Conductor_number=N Winding=WindingC PolarityType=Negative
  Z_5: Coil Objects=Z_5 Conductor_number=N Winding=WindingC PolarityType=Negative
  WindingA: Winding Group Type=External IsSolid=false Current=0 ParallelBranchesNum=1
  WindingB: Winding Group Type=External IsSolid=false Current=0 ParallelBranchesNum=1
  WindingC: Winding Group Type=External IsSolid=false Current=0 ParallelBranchesNum=1
  external circuit: "* Design: RotorySimulink1_ckt"
mesh:
  CylindricalGap1: CylindricalGap Objects=Band Objects=Band
  Region: LengthBased RefineInside Objects=Region MaxLength=8mm
  SR: LengthBased RefineInside Objects=[Stator, #41] MaxLength=4mm
  Band: LengthBased Objects=Band MaxLength=0.5mm
setups:
  Setup1: Transient NonlinearSolverResidual=0.0001 ScalarPotential="Second Order" StopTime="(1/150) s" TimeStep="(1/150/50) s" InitialTimeStep=0.002s MinTimeStep=0.001s MaxTimeStep=0.003s TimeStepErrTolerance=0.0001
field calculator expressions:
  Br = Fundamental_Quantity(22) | 2D_Normal | Dot
  Bt = Fundamental_Quantity(22) | Tangent | Dot
field plots:
  Mesh1: MeshPlots on Setup1 : Transient at Time=-1
  Flux_Lines1: A on Setup1 : Transient at Time=-1
  Mag_B1: B on Setup1 : Transient at Time=-1
reports:
  Winding Plot 1: FluxLinkage(WindingA), FluxLinkage(WindingB), FluxLinkage(WindingC) vs Time on Setup1 : Transient
  Winding Plot 2: InducedVoltage(WindingA), InducedVoltage(WindingB), InducedVoltage(WindingC) vs Time on Setup1 : Transient; markers MY1 at y=0
  Plot 1: L(d - axis), L(q - axis) vs Time on Setup1 : Transient
  Torque Plot 1: Moving1.Torque vs Time on Setup1 : Transient [A=all]
  Winding Plot1: Current(WindingA), Current(WindingB), Current(WindingC) vs Time on Setup1 : Transient
  Plot1: I(d - axis), I(q - axis) vs Time on Setup1 : Transient

design MatlabConnect (Twin Builder)
options: SimplorerConverter(204)
components:
  ECE1 = MaxwellECEData(ComponentDataType=MaxwellECEData name=MaxwellECEData filename=$PROJECTDIR\RotorySimulink.aedt numberofports=8 CouplingDesignName="ECE (Transient)" CouplingType=SmlMaxwell2DECELink MaxNumPoles=10000 ErrTol=0.005 SSZref=50ohm Mw2DDepth=1meter MwScale=1 RefPinStyle=3 Properties{paramProp(ra0, 0.001) paramProp(la0, 1e-06) paramProp(IniIa0, 0) paramProp(IniIb0, 0) paramProp(IniIc0, 0) paramProp(Fluxa0, 0) paramProp(Fluxb0, 0) paramProp(Fluxc0, 0) paramProp(Fluxd0, 0) paramProp(Fluxq0, 0) paramProp(IniPos, 30) paramProp(Pos, 0)} PortInfo{OnePortInfo(A0, -1, "") OnePortInfo(X0, -1, "") OnePortInfo(B0, -1, "") OnePortInfo(Y0, -1, "") OnePortInfo(C0, -1, "") OnePortInfo(Z0, -1, "") OnePortInfo(ROT1, -7, "") OnePortInfo(ROT2, -7, "")})
  AM1 = AM(I=0)
  AM2 = AM(I=0)
  AM3 = AM(I=0)
  FM_ROTB1 = FM_ROTB(TORQUE=0)
  SM_ROTB1 = SM_ROTB(PHI=0)
  VM_ROTB1 = VM_ROTB(OMEGA=0)
  MASS_ROTB1 = MASS_ROTB(J=0.0021kgm2)
  ROTB_ROT1 = ROTB_ROT()
  MDL1 = SimulinkData10(ComponentDataType=SimulinkData name=SimulinkData numberofports=0 SimulinkModelName=SimulinkData1 SimulinkVectorSize=10 SimulinkName0=uA SimulinkValue0=0 SimulinkDirection0=1 SimulinkName1=uB SimulinkValue1=0 SimulinkDirection1=1 SimulinkName2=uC SimulinkValue2=0 SimulinkDirection2=1 SimulinkName3=TL SimulinkValue3=0 SimulinkDirection3=1 SimulinkName4=iA SimulinkValue4=0 SimulinkDirection4=0 SimulinkName5=iB SimulinkValue5=0 SimulinkDirection5=0 SimulinkName6=iC SimulinkValue6=0 SimulinkDirection6=0 SimulinkName7=wm SimulinkValue7=0 SimulinkDirection7=0 SimulinkName8=THM SimulinkValue8=0 SimulinkDirection8=0 SimulinkName9=Te SimulinkValue9=0 SimulinkDirection9=0 iA=AM1.I iB=AM2.I iC=AM3.I Te=FM_ROTB1.TORQUE wm=FM_ROTB1.TORQUE THM=SM_ROTB1.PHI uA=0 uB=0 uC=0 TL=0)
  E1 = E(EMF=MDL1.uA PERIO=0)
  E2 = E(EMF=MDL1.uB PERIO=0)
  E3 = E(EMF=MDL1.uC PERIO=0)
  F_ROTB1 = F_ROTB(VALUE=MDL1.TL PERIO=0)
nets:
  0: F_ROTB1.0, ECE1.ROT2
  iA: MDL1.iA, AM1.I
  iB: MDL1.iB, AM2.I
  iC: AM3.I, MDL1.iC
  net_10: AM2.1, ECE1.B0
  net_11: AM3.1, ECE1.C0
  net_17: ROTB_ROT1.0, FM_ROTB1.0
  net_18: ROTB_ROT1.1, ECE1.ROT1
  net_19: MASS_ROTB1.0, FM_ROTB1.1, VM_ROTB1.0, SM_ROTB1.0, F_ROTB1.1
  net_4: ECE1.X0, ECE1.Y0, ECE1.Z0
  net_5: E1.0, E2.0, E3.0
  net_6: E1.1, AM1.0
  net_7: E2.1, AM2.0
  net_8: AM3.0, E3.1
  net_9: AM1.1, ECE1.A0
  Te: MDL1.Te, MDL1.wm, FM_ROTB1.TORQUE
  THM: MDL1.THM, SM_ROTB1.PHI
  TL: MDL1.TL, F_ROTB1.VALUE
  uA: MDL1.uA, E1.EMF
  uB: MDL1.uB, E2.EMF
  uC: MDL1.uC, E3.EMF
  wm: VM_ROTB1.OMEGA
setups:
  TR: TransientData(1s, 0.01ms, 0.01ms, false, "")

# Ansys Electronics Desktop project, version 2026.1
materials:
  vacuum: permittivity=1
  M250-35A_20C_SF0.97: permeability{HUnit=A_per_meter BUnit=tesla curve (0, 0) (12, 0.1) (24, 0.2) (36, 0.3) (48, 0.4) (60, 0.5) (72, 0.6) (84, 0.7) (96, 0.8) (109, 0.9) (128, 1) (155, 1.1) (200, 1.2) (295, 1.3) (578, 1.4) (1567, 1.5) (3673, 1.6) (6996, 1.7) (13134.9088, 1.8162) (28200.2369, 1.8924) (100790, 1.998) (180370, 2.1) (259950, 2.2) (339530, 2.3) (419110, 2.4) (498690, 2.5)} conductivity=1694915.3 core_loss_type="Electrical Steel" core_loss_kh=193.22165 core_loss_kc=0.35209579 mass_density=7650 stacking_type=Lamination stacking_factor=0.97 stacking_direction=V(3) core_loss_es_y=2
  Copper (Pure)_20C [ref. Temp]: thermal_modifier{Property=conductivity free_form_value=1/(1+0.003862*(Temp-20))} conductivity=58004640
  N30UH_20C [ref. Temp]_2D3DFactMagnet: thermal_modifier{Property=permeability free_form_value="1 - 0.0012*(Temp - 20)"} thermal_modifier{Property=conductivity free_form_value=1} thermal_modifier{Property=magnetic_coercivity free_form_value="1 - 0.00465*(Temp - 20)"} permeability{BTypeForSingleCurve=intrinsic HUnit=A_per_meter BUnit=tesla curve (-1990000, 0) (-1989534.1, 0.027594435) (-1989057.3, 0.055048307) (-1988569.4, 0.082344301) (-1988070, 0.10946499) (-1987558.9, 0.13639287) (-1987035.9, 0.1631104) (-1986500.6, 0.18960004) (-1985952.8, 0.21584428) (-1985392.1, 0.24182568) (-1984818.4, 0.26752693) (-1984231.2, 0.29293087) (-1983630.2, 0.31802056) (-1983015.2, 0.34277929) (-1982385.8, 0.36719067) (-1981741.7, 0.39123862) (-1981082.4, 0.41490749) (-1980407.8, 0.43818203) (-1979717.3, 0.46104749) (-1979010.7, 0.48348965) (-1978287.6, 0.50549488) (-1977547.5, 0.52705015) (-1976790, 0.54814311) (-1976014.9, 0.56876214) (-1975221.6, 0.58889635) (-1974409.7, 0.60853566) (-1973578.8, 0.62767084) (-1972728.5, 0.64629352) (-1971858.3, 0.66439623) (-1970967.7, 0.68197245) (-1970056.2, 0.69901663) (-1969123.4, 0.71552421) (-1968168.8, 0.73149164) (-1967191.8, 0.74691641) (-1966191.9, 0.76179704) (-1965168.7, 0.77613312) (-1964121.4, 0.78992529) (-1963049.7, 0.80317526) (-1961952.9, 0.81588576) (-1960830.4, 0.8280606) (-1959681.6, 0.83970461) (-1958505.9, 0.85082362) (-1957302.7, 0.86142444) (-1956071.3, 0.87151486) (-1954811.1, 0.88110357) (-1953521.4, 0.89020014) (-1952201.5, 0.89881499) (-1950850.7, 0.90695933) (-1949468.3, 0.9146451) (-1948053.5, 0.92188493) (-1946605.5, 0.92869207) (-1945123.7, 0.93508035) (-1943607.2, 0.94106407) (-1942055.2, 0.94665798) (-1940466.9, 0.9518772) (-1938841.4, 0.95673713) (-1937177.8, 0.96125341) (-1935475.2, 0.96544182) (-1933732.9, 0.96931824) (-1931949.7, 0.97289857) (-1930124.8, 0.97619864) (-1928257.1, 0.9792342) (-1926345.7, 0.98202079) (-1924389.6, 0.98457374) (-1922387.7, 0.98690807) (-1920338.9, 0.98903847) (-1918242.2, 0.99097924) (-1916096.3, 0.99274424) (-1913900.2, 0.99434685) (-1911652.7, 0.99579995) (-1909352.6, 0.9971159) (-1906998.7, 0.99830646) (-1904589.6, 0.99938285) (-1902124.2, 1.0003557) (-1899601, 1.001235) (-1897018.7, 1.0020301) (-1894376, 1.0027499) (-1891671.4, 1.0034026) (-1888903.5, 1.0039958) (-1886070.8, 1.0045366) (-1883171.8, 1.0050313) (-1880204.9, 1.0054861) (-1877168.6, 1.0059062) (-1874061.2, 1.0062967) (-1870881, 1.006662) (-1867626.4, 1.0070061) (-1864295.5, 1.0073327) (-1860886.7, 1.0076449) (-1857398.1, 1.0079457) (-1853827.8, 1.0082376) (-1850174, 1.0085229) (-1846434.6, 1.0088035) (-1842607.6, 1.0090812) (-1838691.1, 1.0093575) (-1834682.8, 1.0096338) (-1830580.7, 1.0099111) (-1826382.6, 1.0101905) (-1822086.2, 1.0104728) (-1817689.2, 1.0107589) (-1813189.3, 1.0110493) (-1808584, 1.0113446) (-1803871, 1.0116453) (-1799047.5, 1.0119519) (-1794111.2, 1.0122648) (-1789059.3, 1.0125843) (-1783889.1, 1.0129107) (-1778597.8, 1.0132443) (-1773182.7, 1.0135854) (-1767640.8, 1.0139342) (-1761969.2, 1.0142911) (-1756164.8, 1.0146561) (-1750224.5, 1.0150296) (-1744145.1, 1.0154117) (-1737923.4, 1.0158028) (-1731556.1, 1.0162029) (-1725039.7, 1.0166124) (-1718370.7, 1.0170315) (-1711545.6, 1.0174604) (-1704560.7, 1.0178993) (-1697412.3, 1.0183484)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} conductivity=88909.753 magnetic_coercivity{Magnitude=-1990000A_per_meter DirComp1=1 DirComp2=0 DirComp3=0}
  N30UH_20C_UD90: thermal_modifier{Property=permeability free_form_value="1 - 0.0012*(Temp - 20)"} thermal_modifier{Property=conductivity free_form_value=1} thermal_modifier{Property=magnetic_coercivity free_form_value="1 - 0.00465*(Temp - 20)"} permeability{BTypeForSingleCurve=intrinsic HUnit=A_per_meter BUnit=tesla curve (-1990000, 0) (-1989534.1, 0.027594435) (-1989057.3, 0.055048307) (-1988569.4, 0.082344301) (-1988070, 0.10946499) (-1987558.9, 0.13639287) (-1987035.9, 0.1631104) (-1986500.6, 0.18960004) (-1985952.8, 0.21584428) (-1985392.1, 0.24182568) (-1984818.4, 0.26752693) (-1984231.2, 0.29293087) (-1983630.2, 0.31802056) (-1983015.2, 0.34277929) (-1982385.8, 0.36719067) (-1981741.7, 0.39123862) (-1981082.4, 0.41490749) (-1980407.8, 0.43818203) (-1979717.3, 0.46104749) (-1979010.7, 0.48348965) (-1978287.6, 0.50549488) (-1977547.5, 0.52705015) (-1976790, 0.54814311) (-1976014.9, 0.56876214) (-1975221.6, 0.58889635) (-1974409.7, 0.60853566) (-1973578.8, 0.62767084) (-1972728.5, 0.64629352) (-1971858.3, 0.66439623) (-1970967.7, 0.68197245) (-1970056.2, 0.69901663) (-1969123.4, 0.71552421) (-1968168.8, 0.73149164) (-1967191.8, 0.74691641) (-1966191.9, 0.76179704) (-1965168.7, 0.77613312) (-1964121.4, 0.78992529) (-1963049.7, 0.80317526) (-1961952.9, 0.81588576) (-1960830.4, 0.8280606) (-1959681.6, 0.83970461) (-1958505.9, 0.85082362) (-1957302.7, 0.86142444) (-1956071.3, 0.87151486) (-1954811.1, 0.88110357) (-1953521.4, 0.89020014) (-1952201.5, 0.89881499) (-1950850.7, 0.90695933) (-1949468.3, 0.9146451) (-1948053.5, 0.92188493) (-1946605.5, 0.92869207) (-1945123.7, 0.93508035) (-1943607.2, 0.94106407) (-1942055.2, 0.94665798) (-1940466.9, 0.9518772) (-1938841.4, 0.95673713) (-1937177.8, 0.96125341) (-1935475.2, 0.96544182) (-1933732.9, 0.96931824) (-1931949.7, 0.97289857) (-1930124.8, 0.97619864) (-1928257.1, 0.9792342) (-1926345.7, 0.98202079) (-1924389.6, 0.98457374) (-1922387.7, 0.98690807) (-1920338.9, 0.98903847) (-1918242.2, 0.99097924) (-1916096.3, 0.99274424) (-1913900.2, 0.99434685) (-1911652.7, 0.99579995) (-1909352.6, 0.9971159) (-1906998.7, 0.99830646) (-1904589.6, 0.99938285) (-1902124.2, 1.0003557) (-1899601, 1.001235) (-1897018.7, 1.0020301) (-1894376, 1.0027499) (-1891671.4, 1.0034026) (-1888903.5, 1.0039958) (-1886070.8, 1.0045366) (-1883171.8, 1.0050313) (-1880204.9, 1.0054861) (-1877168.6, 1.0059062) (-1874061.2, 1.0062967) (-1870881, 1.006662) (-1867626.4, 1.0070061) (-1864295.5, 1.0073327) (-1860886.7, 1.0076449) (-1857398.1, 1.0079457) (-1853827.8, 1.0082376) (-1850174, 1.0085229) (-1846434.6, 1.0088035) (-1842607.6, 1.0090812) (-1838691.1, 1.0093575) (-1834682.8, 1.0096338) (-1830580.7, 1.0099111) (-1826382.6, 1.0101905) (-1822086.2, 1.0104728) (-1817689.2, 1.0107589) (-1813189.3, 1.0110493) (-1808584, 1.0113446) (-1803871, 1.0116453) (-1799047.5, 1.0119519) (-1794111.2, 1.0122648) (-1789059.3, 1.0125843) (-1783889.1, 1.0129107) (-1778597.8, 1.0132443) (-1773182.7, 1.0135854) (-1767640.8, 1.0139342) (-1761969.2, 1.0142911) (-1756164.8, 1.0146561) (-1750224.5, 1.0150296) (-1744145.1, 1.0154117) (-1737923.4, 1.0158028) (-1731556.1, 1.0162029) (-1725039.7, 1.0166124) (-1718370.7, 1.0170315) (-1711545.6, 1.0174604) (-1704560.7, 1.0178993) (-1697412.3, 1.0183484)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} conductivity=88909.753 magnetic_coercivity{Magnitude=-1990000A_per_meter DirComp1=1 DirComp2=0 DirComp3=0}

design PMSM_Healthy (Maxwell 2D, Transient, XY geometry, model units mm)
options: ModelDepth=Magnetic_Axial_Length
variables:
  Is_2D_Design = 1
  DiaGap = 132mm
  DiaStatorYoke = 198mm
  DiaShaft = 80mm
  DiaShaft_Effective = 80mm
  DiaOuter = 198mm
  Airgap = 1mm
  StatorSkewAngle = 0deg
  Model_Length = 0mm
  Magnet_Length = 150mm
  Stator_Lam_Length = 0mm
  Rotor_Lam_Length = 0mm
  RotorDia = 130mm
  Rotor_Slices = 1
  SlotNumber_Stator = 48
  SlotType_Stator = 3
  Hs0_Stator = 1mm
  Hs1_Stator = 0.33497334mm
  Hs2_Stator = 17.541151mm
  Bs0_Stator = 3mm
  Bs1_Stator = 4.3148444mm
  Bs2_Stator = 6.61426mm
  Rs_Stator = 2mm
  FilletType_Stator = 3
  Magnetic_Axial_Length = 150mm
  Layers = 1
  ParallelPaths = 2
  SpanExt = 25.214884mm
  WdgExt_Avg = 5mm
  HalfAxial = 0
  SymmetryFactor = 1
  SegAngle = 0deg
  SegAngle_Coil_Armature = 10deg
  NumPoles = 8
  Magnet_Axial_Offset = 0mm
  Axial_Segments = 18
  PoleType_VPMCore = 1
  L1_ThicknessDuct = 6.2mm
  L1_WidthDuct = 17mm
  L1_ThicknessBridge = 1mm
  L1_ExtOuter = 2mm
  L1_ExtInner = 2mm
  L1_PoleVAngle = 150deg
  L1_ArcPole = 155deg
  L1_ThicknessPost = 0.5mm
  L1_DminMag = 4.5631061mm
  L1_WidthMagnet = 16mm
  L1_InnerGapMagnet = 0.2mm
  Shaft_Hole_Diameter = 0mm
  Sleeve_Thickness = 0mm
  Banding_Thickness = 0mm
  IPeak = 433A
  PhaseAdvance = 65.79deg
  MachineRPM = 6000rpm
  Vpeak = 405.78194V
  Rphase = 0.013377364ohm
  PhasorAngle = 29.390739deg
  MaxPhasorAngle = 120deg
  PeakDriveVoltage = Vpeak / (2*sin(MaxPhasorAngle / 2))
  Lend = 6.0269258e-06H
  NumTorqueCycles = 1
  NumTorquePointsPerCycle = 30
  DriveOffsetED = 0deg
  InitialPositionMD = -DriveOffsetED / (NumPoles/2)
geometry:
  Stator_Lamination_Primitive [M250-35A_20C_SF0.97] = user_primitive(RMxprt/VentSlotCore.dll, DiaGap=DiaGap, DiaYoke=DiaStatorYoke, Length=Stator_Lam_Length, Skew=StatorSkewAngle, Slots=SlotNumber_Stator, SlotType=SlotType_Stator, Hs0=Hs0_Stator, Hs01=0mm, Hs1=Hs1_Stator, Hs2=17.541151mm, Bs0=Bs0_Stator, Bs1=4.3148444mm, Bs2=6.61426mm, Rs=Rs_Stator, FilletType=FilletType_Stator, HalfSlot=0, VentHoles=0, HoleDiaIn=0mm, HoleDiaOut=0mm, HoleLocIn=0mm, HoleLocOut=0mm, VentDucts=0, DuctWidth=0mm, DuctPitch=0mm, SegAngle=SegAngle, LenRegion=0mm, InfoCore=0)
  Rotor_1 [M250-35A_20C_SF0.97] = circle(normal=Z, centre=(0mm, 0mm, 0mm), radius=65mm)
  Rotor_Subtract_6 = circle(normal=Z, centre=(0mm, 0mm, 0mm), radius=40mm)
  Rotor_1.subtract(Rotor_Subtract_6)
  Rotor_Pocket [vacuum] = polyline(z=0mm, xy in mm: (-63.2908, 7.3463) (-63.5952, 6.9496) (-62.3533, 3.4757) (-58.6764, 3.1753) (-58.372, 3.572) (-48.6318, 16.2656) (-48.3274, 16.6623) (-49.5693, 20.1362) (-53.2462, 20.4366) (-53.5506, 20.0399) (-63.2908, 7.3463), closed, covered, Arc from point 1 over 3, Arc from point 6 over 3)
  coordinate_system CS_L1_1Magnet2S3_1 = origin=(-56.04069mm, 11.866879mm, 0mm) x=(0.84432629mm, -0.64787435mm, 0mm) y=(0.64787435mm, 0.84432629mm, 0mm)
  L1_1Magnet2S3_1 [N30UH_20C [ref. Temp]_2D3DFactMagnet, oriented by CS_L1_1Magnet2S3_1] = polyline(z=0mm, xy in mm: (-63.2908, 7.3463) (-58.5307, 3.6937) (-48.7905, 16.3874) (-53.5506, 20.0399) (-63.2908, 7.3463), closed, covered)
  Rotor_Pocket_1 [vacuum] = polyline(z=0mm, xy in mm: (-63.5952, -6.9496) (-63.2908, -7.3463) (-53.5506, -20.0399) (-53.2462, -20.4366) (-49.5693, -20.1362) (-48.3274, -16.6623) (-48.6318, -16.2656) (-58.372, -3.572) (-58.6764, -3.1753) (-62.3533, -3.4757) (-63.5952, -6.9496), closed, covered, Arc from point 3 over 3, Arc from point 8 over 3)
  coordinate_system CS_L1_1Magnet1N3_1 = origin=(-56.04069mm, -11.866879mm, 0mm) x=(-0.84432629mm, -0.64787435mm, 0mm) y=(0.64787435mm, -0.84432629mm, 0mm)
  L1_1Magnet1N3_1 [N30UH_20C [ref. Temp]_2D3DFactMagnet, oriented by CS_L1_1Magnet1N3_1] = polyline(z=0mm, xy in mm: (-58.5307, -3.6937) (-63.2908, -7.3463) (-53.5506, -20.0399) (-48.7905, -16.3874) (-58.5307, -3.6937), closed, covered)
  Rotor_Pocket_2 [vacuum] = polyline(z=0mm, xy in mm: (-63.0692, 15.7249) (-61.7463, 16.8339) (-62.3232, 18.4609) (-62.7111, 17.097) (-63.0692, 15.7249), closed, covered, Arc from point 2 over 3)
  Rotor_Pocket_3 [vacuum] = polyline(z=0mm, xy in mm: (-63.0692, -15.7249) (-62.7111, -17.097) (-62.3232, -18.4609) (-61.7463, -16.8339) (-63.0692, -15.7249), closed, covered, Arc from point 0 over 3)
  Rotor_Pocket_4 [vacuum] = polyline(z=0mm, xy in mm: (-52.1017, -23.1998) (-52.0364, -23.6956) (-49.948, -39.5587) (-49.8827, -40.0544) (-46.5482, -41.6327) (-43.7358, -39.2451) (-43.801, -38.7494) (-45.8894, -22.8863) (-45.9547, -22.3906) (-49.2892, -20.8123) (-52.1017, -23.1998), closed, covered, Arc from point 3 over 3, Arc from point 8 over 3)
  coordinate_system CS_L1_1Magnet2N3_1 = origin=(-48.017903mm, -31.235601mm, 0mm) x=(-1.0551452mm, -0.1389125mm, 0mm) y=(0.1389125mm, -1.0551452mm, 0mm)
  L1_1Magnet2N3_1 [N30UH_20C [ref. Temp]_2D3DFactMagnet, oriented by CS_L1_1Magnet2N3_1] = polyline(z=0mm, xy in mm: (-49.948, -39.5587) (-43.9993, -38.7755) (-46.0877, -22.9124) (-52.0364, -23.6956) (-49.948, -39.5587), closed, covered)
  Rotor_Pocket_5 [vacuum] = polyline(z=0mm, xy in mm: (-39.5587, 49.948) (-40.0544, 49.8827) (-41.6327, 46.5482) (-39.2451, 43.7358) (-38.7494, 43.801) (-22.8863, 45.8894) (-22.3906, 45.9547) (-20.8123, 49.2892) (-23.1998, 52.1017) (-23.6956, 52.0364) (-39.5587, 49.948), closed, covered, Arc from point 1 over 3, Arc from point 6 over 3)
  coordinate_system CS_L1_1Magnet2N2_1 = origin=(-31.235601mm, 48.017903mm, 0mm) x=(-0.1389125mm, 1.0551452mm, 0mm) y=(-1.0551452mm, -0.1389125mm, 0mm)
  L1_1Magnet2N2_1 [N30UH_20C [ref. Temp]_2D3DFactMagnet, oriented by CS_L1_1Magnet2N2_1] = polyline(z=0mm, xy in mm: (-39.5587, 49.948) (-38.7755, 43.9993) (-22.9124, 46.0877) (-23.6956, 52.0364) (-39.5587, 49.948), closed, covered)
  Rotor_Pocket_6 [vacuum] = polyline(z=0mm, xy in mm: (-20.4366, -53.2462) (-20.0399, -53.5506) (-7.3463, -63.2908) (-6.9496, -63.5952) (-3.4757, -62.3533) (-3.1753, -58.6764) (-3.572, -58.372) (-16.2656, -48.6318) (-16.6623, -48.3274) (-20.1362, -49.5693) (-20.4366, -53.2462), closed, covered, Arc from point 3 over 3, Arc from point 8 over 3)
  coordinate_system CS_L1_1Magnet2S4_1 = origin=(-11.866879mm, -56.04069mm, 0mm) x=(0.64787435mm, 0.84432629mm, 0mm) y=(-0.84432629mm, 0.64787435mm, 0mm)
  L1_1Magnet2S4_1 [N30UH_20C [ref. Temp]_2D3DFactMagnet, oriented by CS_L1_1Magnet2S4_1] = polyline(z=0mm, xy in mm: (-7.3463, -63.2908) (-3.6937, -58.5307) (-16.3874, -48.7905) (-20.0399, -53.5506) (-7.3463, -63.2908), closed, covered)
  Rotor_Pocket_7 [vacuum] = polyline(z=0mm, xy in mm: (3.1753, 58.6764) (3.572, 58.372) (16.2656, 48.6318) (16.6623, 48.3274) (20.1362, 49.5693) (20.4366, 53.2462) (20.0399, 53.5506) (7.3463, 63.2908) (6.9496, 63.5952) (3.4757, 62.3533) (3.1753, 58.6764), closed, covered, Arc from point 3 over 3, Arc from point 8 over 3)
  coordinate_system CS_L1_1Magnet2S2_1 = origin=(11.866879mm, 56.04069mm, 0mm) x=(-0.64787435mm, -0.84432629mm, 0mm) y=(0.84432629mm, -0.64787435mm, 0mm)
  L1_1Magnet2S2_1 [N30UH_20C [ref. Temp]_2D3DFactMagnet, oriented by CS_L1_1Magnet2S2_1] = polyline(z=0mm, xy in mm: (7.3463, 63.2908) (3.6937, 58.5307) (16.3874, 48.7905) (20.0399, 53.5506) (7.3463, 63.2908), closed, covered)
  Rotor_Pocket_8 [vacuum] = polyline(z=0mm, xy in mm: (22.8863, -45.8894) (22.3906, -45.9547) (20.8123, -49.2892) (23.1998, -52.1017) (23.6956, -52.0364) (39.5587, -49.948) (40.0544, -49.8827) (41.6327, -46.5482) (39.2451, -43.7358) (38.7494, -43.801) (22.8863, -45.8894), closed, covered, Arc from point 1 over 3, Arc from point 6 over 3)
  coordinate_system CS_L1_1Magnet2N4_1 = origin=(31.235601mm, -48.017903mm, 0mm) x=(0.1389125mm, -1.0551452mm, 0mm) y=(1.0551452mm, 0.1389125mm, 0mm)
  L1_1Magnet2N4_1 [N30UH_20C [ref. Temp]_2D3DFactMagnet, oriented by CS_L1_1Magnet2N4_1] = polyline(z=0mm, xy in mm: (39.5587, -49.948) (38.7755, -43.9993) (22.9124, -46.0877) (23.6956, -52.0364) (39.5587, -49.948), closed, covered)
  Rotor_Pocket_9 [vacuum] = polyline(z=0mm, xy in mm: (43.7358, 39.2451) (43.801, 38.7494) (45.8894, 22.8863) (45.9547, 22.3906) (49.2892, 20.8123) (52.1017, 23.1998) (52.0364, 23.6956) (49.948, 39.5587) (49.8827, 40.0544) (46.5482, 41.6327) (43.7358, 39.2451), closed, covered, Arc from point 3 over 3, Arc from point 8 over 3)
  coordinate_system CS_L1_1Magnet2N1_1 = origin=(48.017903mm, 31.235601mm, 0mm) x=(1.0551452mm, 0.1389125mm, 0mm) y=(-0.1389125mm, 1.0551452mm, 0mm)
  L1_1Magnet2N1_1 [N30UH_20C [ref. Temp]_2D3DFactMagnet, oriented by CS_L1_1Magnet2N1_1] = polyline(z=0mm, xy in mm: (49.948, 39.5587) (43.9993, 38.7755) (46.0877, 22.9124) (52.0364, 23.6956) (49.948, 39.5587), closed, covered)
  Rotor_Pocket_10 [vacuum] = polyline(z=0mm, xy in mm: (48.6318, -16.2656) (48.3274, -16.6623) (49.5693, -20.1362) (53.2462, -20.4366) (53.5506, -20.0399) (63.2908, -7.3463) (63.5952, -6.9496) (62.3533, -3.4757) (58.6764, -3.1753) (58.372, -3.572) (48.6318, -16.2656), closed, covered, Arc from point 1 over 3, Arc from point 6 over 3)
  coordinate_system CS_L1_1Magnet2S1_1 = origin=(56.04069mm, -11.866879mm, 0mm) x=(-0.84432629mm, 0.64787435mm, 0mm) y=(-0.64787435mm, -0.84432629mm, 0mm)
  L1_1Magnet2S1_1 [N30UH_20C [ref. Temp]_2D3DFactMagnet, oriented by CS_L1_1Magnet2S1_1] = polyline(z=0mm, xy in mm: (63.2908, -7.3463) (58.5307, -3.6937) (48.7905, -16.3874) (53.5506, -20.0399) (63.2908, -7.3463), closed, covered)
  Rotor_Pocket_11 [vacuum] = polyline(z=0mm, xy in mm: (-52.0364, 23.6956) (-52.1017, 23.1998) (-49.2892, 20.8123) (-45.9547, 22.3906) (-45.8894, 22.8863) (-43.801, 38.7494) (-43.7358, 39.2451) (-46.5482, 41.6327) (-49.8827, 40.0544) (-49.948, 39.5587) (-52.0364, 23.6956), closed, covered, Arc from point 1 over 3, Arc from point 6 over 3)
  coordinate_system CS_L1_1Magnet1S3_1 = origin=(-48.017903mm, 31.235601mm, 0mm) x=(1.0551452mm, -0.1389125mm, 0mm) y=(0.1389125mm, 1.0551452mm, 0mm)
  L1_1Magnet1S3_1 [N30UH_20C [ref. Temp]_2D3DFactMagnet, oriented by CS_L1_1Magnet1S3_1] = polyline(z=0mm, xy in mm: (-43.9993, 38.7755) (-49.948, 39.5587) (-52.0364, 23.6956) (-46.0877, 22.9124) (-43.9993, 38.7755), closed, covered)
  Rotor_Pocket_12 [vacuum] = polyline(z=0mm, xy in mm: (-40.0544, -49.8827) (-39.5587, -49.948) (-23.6956, -52.0364) (-23.1998, -52.1017) (-20.8123, -49.2892) (-22.3906, -45.9547) (-22.8863, -45.8894) (-38.7494, -43.801) (-39.2451, -43.7358) (-41.6327, -46.5482) (-40.0544, -49.8827), closed, covered, Arc from point 3 over 3, Arc from point 8 over 3)
  coordinate_system CS_L1_1Magnet1S4_1 = origin=(-31.235601mm, -48.017903mm, 0mm) x=(0.1389125mm, 1.0551452mm, 0mm) y=(-1.0551452mm, 0.1389125mm, 0mm)
  L1_1Magnet1S4_1 [N30UH_20C [ref. Temp]_2D3DFactMagnet, oriented by CS_L1_1Magnet1S4_1] = polyline(z=0mm, xy in mm: (-38.7755, -43.9993) (-39.5587, -49.948) (-23.6956, -52.0364) (-22.9124, -46.0877) (-38.7755, -43.9993), closed, covered)
  Rotor_Pocket_13 [vacuum] = polyline(z=0mm, xy in mm: (-20.0399, 53.5506) (-20.4366, 53.2462) (-20.1362, 49.5693) (-16.6623, 48.3274) (-16.2656, 48.6318) (-3.572, 58.372) (-3.1753, 58.6764) (-3.4757, 62.3533) (-6.9496, 63.5952) (-7.3463, 63.2908) (-20.0399, 53.5506), closed, covered, Arc from point 1 over 3, Arc from point 6 over 3)
  coordinate_system CS_L1_1Magnet1N2_1 = origin=(-11.866879mm, 56.04069mm, 0mm) x=(-0.64787435mm, 0.84432629mm, 0mm) y=(-0.84432629mm, -0.64787435mm, 0mm)
  L1_1Magnet1N2_1 [N30UH_20C [ref. Temp]_2D3DFactMagnet, oriented by CS_L1_1Magnet1N2_1] = polyline(z=0mm, xy in mm: (-3.6937, 58.5307) (-7.3463, 63.2908) (-20.0399, 53.5506) (-16.3874, 48.7905) (-3.6937, 58.5307), closed, covered)
  Rotor_Pocket_14 [vacuum] = polyline(z=0mm, xy in mm: (3.572, -58.372) (3.1753, -58.6764) (3.4757, -62.3533) (6.9496, -63.5952) (7.3463, -63.2908) (20.0399, -53.5506) (20.4366, -53.2462) (20.1362, -49.5693) (16.6623, -48.3274) (16.2656, -48.6318) (3.572, -58.372), closed, covered, Arc from point 1 over 3, Arc from point 6 over 3)
  coordinate_system CS_L1_1Magnet1N4_1 = origin=(11.866879mm, -56.04069mm, 0mm) x=(0.64787435mm, -0.84432629mm, 0mm) y=(0.84432629mm, 0.64787435mm, 0mm)
  L1_1Magnet1N4_1 [N30UH_20C [ref. Temp]_2D3DFactMagnet, oriented by CS_L1_1Magnet1N4_1] = polyline(z=0mm, xy in mm: (3.6937, -58.5307) (7.3463, -63.2908) (20.0399, -53.5506) (16.3874, -48.7905) (3.6937, -58.5307), closed, covered)
  Rotor_Pocket_15 [vacuum] = polyline(z=0mm, xy in mm: (22.3906, 45.9547) (22.8863, 45.8894) (38.7494, 43.801) (39.2451, 43.7358) (41.6327, 46.5482) (40.0544, 49.8827) (39.5587, 49.948) (23.6956, 52.0364) (23.1998, 52.1017) (20.8123, 49.2892) (22.3906, 45.9547), closed, covered, Arc from point 3 over 3, Arc from point 8 over 3)
  coordinate_system CS_L1_1Magnet1S2_1 = origin=(31.235601mm, 48.017903mm, 0mm) x=(-0.1389125mm, -1.0551452mm, 0mm) y=(1.0551452mm, -0.1389125mm, 0mm)
  L1_1Magnet1S2_1 [N30UH_20C [ref. Temp]_2D3DFactMagnet, oriented by CS_L1_1Magnet1S2_1] = polyline(z=0mm, xy in mm: (38.7755, 43.9993) (39.5587, 49.948) (23.6956, 52.0364) (22.9124, 46.0877) (38.7755, 43.9993), closed, covered)
  Rotor_Pocket_16 [vacuum] = polyline(z=0mm, xy in mm: (43.7358, -39.2451) (46.5482, -41.6327) (49.8827, -40.0544) (49.948, -39.5587) (52.0364, -23.6956) (52.1017, -23.1998) (49.2892, -20.8123) (45.9547, -22.3906) (45.8894, -22.8863) (43.801, -38.7494) (43.7358, -39.2451), closed, covered, Arc from point 0 over 3, Arc from point 5 over 3)
  coordinate_system CS_L1_1Magnet1S1_1 = origin=(48.017903mm, -31.235601mm, 0mm) x=(-1.0551452mm, 0.1389125mm, 0mm) y=(-0.1389125mm, -1.0551452mm, 0mm)
  L1_1Magnet1S1_1 [N30UH_20C [ref. Temp]_2D3DFactMagnet, oriented by CS_L1_1Magnet1S1_1] = polyline(z=0mm, xy in mm: (43.9993, -38.7755) (49.948, -39.5587) (52.0364, -23.6956) (46.0877, -22.9124) (43.9993, -38.7755), closed, covered)
  Rotor_Pocket_17 [vacuum] = polyline(z=0mm, xy in mm: (48.3274, 16.6623) (48.6318, 16.2656) (58.372, 3.572) (58.6764, 3.1753) (62.3533, 3.4757) (63.5952, 6.9496) (63.2908, 7.3463) (53.5506, 20.0399) (53.2462, 20.4366) (49.5693, 20.1362) (48.3274, 16.6623), closed, covered, Arc from point 3 over 3, Arc from point 8 over 3)
  coordinate_system CS_L1_1Magnet1N1_1 = origin=(56.04069mm, 11.866879mm, 0mm) x=(0.84432629mm, 0.64787435mm, 0mm) y=(-0.64787435mm, 0.84432629mm, 0mm)
  L1_1Magnet1N1_1 [N30UH_20C [ref. Temp]_2D3DFactMagnet, oriented by CS_L1_1Magnet1N1_1] = polyline(z=0mm, xy in mm: (58.5307, 3.6937) (63.2908, 7.3463) (53.5506, 20.0399) (48.7905, 16.3874) (58.5307, 3.6937), closed, covered)
  Rotor_Pocket_18 [vacuum] = polyline(z=0mm, xy in mm: (-57.1231, -31.0153) (-56.4329, -32.254) (-55.7158, -33.4774) (-55.5647, -31.7578) (-57.1231, -31.0153), closed, covered, Arc from point 0 over 3)
  Rotor_Pocket_19 [vacuum] = polyline(z=0mm, xy in mm: (-33.4774, 55.7158) (-31.7578, 55.5647) (-31.0153, 57.1231) (-32.254, 56.4329) (-33.4774, 55.7158), closed, covered, Arc from point 2 over 3)
  Rotor_Pocket_20 [vacuum] = polyline(z=0mm, xy in mm: (-18.4609, -62.3232) (-17.097, -62.7111) (-15.7249, -63.0692) (-16.8339, -61.7463) (-18.4609, -62.3232), closed, covered, Arc from point 0 over 3)
  Rotor_Pocket_21 [vacuum] = polyline(z=0mm, xy in mm: (15.7249, 63.0692) (16.8339, 61.7463) (18.4609, 62.3232) (17.097, 62.7111) (15.7249, 63.0692), closed, covered, Arc from point 2 over 3)
  Rotor_Pocket_22 [vacuum] = polyline(z=0mm, xy in mm: (31.0153, -57.1231) (32.254, -56.4329) (33.4774, -55.7158) (31.7578, -55.5647) (31.0153, -57.1231), closed, covered, Arc from point 0 over 3)
  Rotor_Pocket_23 [vacuum] = polyline(z=0mm, xy in mm: (55.7158, 33.4774) (55.5647, 31.7578) (57.1231, 31.0153) (56.4329, 32.254) (55.7158, 33.4774), closed, covered, Arc from point 2 over 3)
  Rotor_Pocket_24 [vacuum] = polyline(z=0mm, xy in mm: (63.0692, -15.7249) (61.7463, -16.8339) (62.3232, -18.4609) (62.7111, -17.097) (63.0692, -15.7249), closed, covered, Arc from point 2 over 3)
  Rotor_Pocket_25 [vacuum] = polyline(z=0mm, xy in mm: (-57.1231, 31.0153) (-55.5647, 31.7578) (-55.7158, 33.4774) (-56.4329, 32.254) (-57.1231, 31.0153), closed, covered, Arc from point 2 over 3)
  Rotor_Pocket_26 [vacuum] = polyline(z=0mm, xy in mm: (-33.4774, -55.7158) (-32.254, -56.4329) (-31.0153, -57.1231) (-31.7578, -55.5647) (-33.4774, -55.7158), closed, covered, Arc from point 0 over 3)
  Rotor_Pocket_27 [vacuum] = polyline(z=0mm, xy in mm: (-18.4609, 62.3232) (-16.8339, 61.7463) (-15.7249, 63.0692) (-17.097, 62.7111) (-18.4609, 62.3232), closed, covered, Arc from point 2 over 3)
  Rotor_Pocket_28 [vacuum] = polyline(z=0mm, xy in mm: (15.7249, -63.0692) (17.097, -62.7111) (18.4609, -62.3232) (16.8339, -61.7463) (15.7249, -63.0692), closed, covered, Arc from point 0 over 3)
  Rotor_Pocket_29 [vacuum] = polyline(z=0mm, xy in mm: (31.0153, 57.1231) (31.7578, 55.5647) (33.4774, 55.7158) (32.254, 56.4329) (31.0153, 57.1231), closed, covered, Arc from point 2 over 3)
  Rotor_Pocket_30 [vacuum] = polyline(z=0mm, xy in mm: (55.5647, -31.7578) (55.7158, -33.4774) (56.4329, -32.254) (57.1231, -31.0153) (55.5647, -31.7578), closed, covered, Arc from point 1 over 3)
  Rotor_Pocket_31 [vacuum] = polyline(z=0mm, xy in mm: (61.7463, 16.8339) (63.0692, 15.7249) (62.7111, 17.097) (62.3232, 18.4609) (61.7463, 16.8339), closed, covered, Arc from point 1 over 3)
  Shaft [vacuum] = circle(normal=Z, centre=(0mm, 0mm, 0mm), radius=40mm)
  Ph1_P1_C1_1 [Copper (Pure)_20C [ref. Temp]] = user_primitive(RMxprt/LapCoil.dll, DiaGap=132mm, DiaYoke=DiaStatorYoke, Length=Stator_Lam_Length, Skew=StatorSkewAngle, Slots=SlotNumber_Stator, SlotType=SlotType_Stator, Hs0=Hs0_Stator, Hs1=Hs1_Stator, Hs2=17.541151mm, Bs0=Bs0_Stator, Bs1=4.3148444mm, Bs2=6.61426mm, Rs=Rs_Stator, FilletType=FilletType_Stator, Layers=Layers, CoilPitch=5, EndExt=WdgExt_Avg, SpanExt=SpanExt, BendAngle=0deg, SegAngle=SegAngle_Coil_Armature, LenRegion=Model_Length, InfoCoil=1)
  Ph1_P1_C1_1.rotate(axis=Z, angle=315deg)
  Ph1_P1_C2_1 [Copper (Pure)_20C [ref. Temp]] = user_primitive(RMxprt/LapCoil.dll, DiaGap=132mm, DiaYoke=DiaStatorYoke, Length=Stator_Lam_Length, Skew=StatorSkewAngle, Slots=SlotNumber_Stator, SlotType=SlotType_Stator, Hs0=Hs0_Stator, Hs1=Hs1_Stator, Hs2=17.541151mm, Bs0=Bs0_Stator, Bs1=4.3148444mm, Bs2=6.61426mm, Rs=Rs_Stator, FilletType=FilletType_Stator, Layers=Layers, CoilPitch=5, EndExt=WdgExt_Avg, SpanExt=SpanExt, BendAngle=0deg, SegAngle=SegAngle_Coil_Armature, LenRegion=Model_Length, InfoCoil=1)
  Ph1_P1_C2_1.rotate(axis=Z, angle=270deg)
  Ph1_P1_C3_1 [Copper (Pure)_20C [ref. Temp]] = user_primitive(RMxprt/LapCoil.dll, DiaGap=132mm, DiaYoke=DiaStatorYoke, Length=Stator_Lam_Length, Skew=StatorSkewAngle, Slots=SlotNumber_Stator, SlotType=SlotType_Stator, Hs0=Hs0_Stator, Hs1=Hs1_Stator, Hs2=17.541151mm, Bs0=Bs0_Stator, Bs1=4.3148444mm, Bs2=6.61426mm, Rs=Rs_Stator, FilletType=FilletType_Stator, Layers=Layers, CoilPitch=5, EndExt=WdgExt_Avg, SpanExt=SpanExt, BendAngle=0deg, SegAngle=SegAngle_Coil_Armature, LenRegion=Model_Length, InfoCoil=1)
  Ph1_P1_C3_1.rotate(axis=Z, angle=225deg)
  Ph1_P1_C4_1 [Copper (Pure)_20C [ref. Temp]] = user_primitive(RMxprt/LapCoil.dll, DiaGap=132mm, DiaYoke=DiaStatorYoke, Length=Stator_Lam_Length, Skew=StatorSkewAngle, Slots=SlotNumber_Stator, SlotType=SlotType_Stator, Hs0=Hs0_Stator, Hs1=Hs1_Stator, Hs2=17.541151mm, Bs0=Bs0_Stator, Bs1=4.3148444mm, Bs2=6.61426mm, Rs=Rs_Stator, FilletType=FilletType_Stator, Layers=Layers, CoilPitch=5, EndExt=WdgExt_Avg, SpanExt=SpanExt, BendAngle=0deg, SegAngle=SegAngle_Coil_Armature, LenRegion=Model_Length, InfoCoil=1)
  Ph1_P1_C4_1.rotate(axis=Z, angle=180deg)
  Ph1_P2_C1_1 [Copper (Pure)_20C [ref. Temp]] = user_primitive(RMxprt/LapCoil.dll, DiaGap=132mm, DiaYoke=DiaStatorYoke, Length=Stator_Lam_Length, Skew=StatorSkewAngle, Slots=SlotNumber_Stator, SlotType=SlotType_Stator, Hs0=Hs0_Stator, Hs1=Hs1_Stator, Hs2=17.541151mm, Bs0=Bs0_Stator, Bs1=4.3148444mm, Bs2=6.61426mm, Rs=Rs_Stator, FilletType=FilletType_Stator, Layers=Layers, CoilPitch=5, EndExt=WdgExt_Avg, SpanExt=SpanExt, BendAngle=0deg, SegAngle=SegAngle_Coil_Armature, LenRegion=Model_Length, InfoCoil=1)
  Ph1_P2_C1_1.rotate(axis=Z, angle=135deg)
  Ph1_P2_C2_1 [Copper (Pure)_20C [ref. Temp]] = user_primitive(RMxprt/LapCoil.dll, DiaGap=132mm, DiaYoke=DiaStatorYoke, Length=Stator_Lam_Length, Skew=StatorSkewAngle, Slots=SlotNumber_Stator, SlotType=SlotType_Stator, Hs0=Hs0_Stator, Hs1=Hs1_Stator, Hs2=17.541151mm, Bs0=Bs0_Stator, Bs1=4.3148444mm, Bs2=6.61426mm, Rs=Rs_Stator, FilletType=FilletType_Stator, Layers=Layers, CoilPitch=5, EndExt=WdgExt_Avg, SpanExt=SpanExt, BendAngle=0deg, SegAngle=SegAngle_Coil_Armature, LenRegion=Model_Length, InfoCoil=1)
  Ph1_P2_C2_1.rotate(axis=Z, angle=90deg)
  Ph1_P2_C3_1 [Copper (Pure)_20C [ref. Temp]] = user_primitive(RMxprt/LapCoil.dll, DiaGap=132mm, DiaYoke=DiaStatorYoke, Length=Stator_Lam_Length, Skew=StatorSkewAngle, Slots=SlotNumber_Stator, SlotType=SlotType_Stator, Hs0=Hs0_Stator, Hs1=Hs1_Stator, Hs2=17.541151mm, Bs0=Bs0_Stator, Bs1=4.3148444mm, Bs2=6.61426mm, Rs=Rs_Stator, FilletType=FilletType_Stator, Layers=Layers, CoilPitch=5, EndExt=WdgExt_Avg, SpanExt=SpanExt, BendAngle=0deg, SegAngle=SegAngle_Coil_Armature, LenRegion=Model_Length, InfoCoil=1)
  Ph1_P2_C3_1.rotate(axis=Z, angle=45deg)
  Ph1_P2_C4_1 [Copper (Pure)_20C [ref. Temp]] = user_primitive(RMxprt/LapCoil.dll, DiaGap=132mm, DiaYoke=DiaStatorYoke, Length=Stator_Lam_Length, Skew=StatorSkewAngle, Slots=SlotNumber_Stator, SlotType=SlotType_Stator, Hs0=Hs0_Stator, Hs1=Hs1_Stator, Hs2=17.541151mm, Bs0=Bs0_Stator, Bs1=4.3148444mm, Bs2=6.61426mm, Rs=Rs_Stator, FilletType=FilletType_Stator, Layers=Layers, CoilPitch=5, EndExt=WdgExt_Avg, SpanExt=SpanExt, BendAngle=0deg, SegAngle=SegAngle_Coil_Armature, LenRegion=Model_Length, InfoCoil=1)
  Ph1_P2_C4_1.rotate(axis=Z, angle=0deg)
  Ph2_P1_C1_1 [Copper (Pure)_20C [ref. Temp]] = user_primitive(RMxprt/LapCoil.dll, DiaGap=132mm, DiaYoke=DiaStatorYoke, Length=Stator_Lam_Length, Skew=StatorSkewAngle, Slots=SlotNumber_Stator, SlotType=SlotType_Stator, Hs0=Hs0_Stator, Hs1=Hs1_Stator, Hs2=17.541151mm, Bs0=Bs0_Stator, Bs1=4.3148444mm, Bs2=6.61426mm, Rs=Rs_Stator, FilletType=FilletType_Stator, Layers=Layers, CoilPitch=5, EndExt=WdgExt_Avg, SpanExt=SpanExt, BendAngle=0deg, SegAngle=SegAngle_Coil_Armature, LenRegion=Model_Length, InfoCoil=1)
  Ph2_P1_C1_1.rotate(axis=Z, angle=195deg)
  Ph2_P1_C2_1 [Copper (Pure)_20C [ref. Temp]] = user_primitive(RMxprt/LapCoil.dll, DiaGap=132mm, DiaYoke=DiaStatorYoke, Length=Stator_Lam_Length, Skew=StatorSkewAngle, Slots=SlotNumber_Stator, SlotType=SlotType_Stator, Hs0=Hs0_Stator, Hs1=Hs1_Stator, Hs2=17.541151mm, Bs0=Bs0_Stator, Bs1=4.3148444mm, Bs2=6.61426mm, Rs=Rs_Stator, FilletType=FilletType_Stator, Layers=Layers, CoilPitch=5, EndExt=WdgExt_Avg, SpanExt=SpanExt, BendAngle=0deg, SegAngle=SegAngle_Coil_Armature, LenRegion=Model_Length, InfoCoil=1)
  Ph2_P1_C2_1.rotate(axis=Z, angle=150deg)
  Ph2_P1_C3_1 [Copper (Pure)_20C [ref. Temp]] = user_primitive(RMxprt/LapCoil.dll, DiaGap=132mm, DiaYoke=DiaStatorYoke, Length=Stator_Lam_Length, Skew=StatorSkewAngle, Slots=SlotNumber_Stator, SlotType=SlotType_Stator, Hs0=Hs0_Stator, Hs1=Hs1_Stator, Hs2=17.541151mm, Bs0=Bs0_Stator, Bs1=4.3148444mm, Bs2=6.61426mm, Rs=Rs_Stator, FilletType=FilletType_Stator, Layers=Layers, CoilPitch=5, EndExt=WdgExt_Avg, SpanExt=SpanExt, BendAngle=0deg, SegAngle=SegAngle_Coil_Armature, LenRegion=Model_Length, InfoCoil=1)
  Ph2_P1_C3_1.rotate(axis=Z, angle=105deg)
  Ph2_P1_C4_1 [Copper (Pure)_20C [ref. Temp]] = user_primitive(RMxprt/LapCoil.dll, DiaGap=132mm, DiaYoke=DiaStatorYoke, Length=Stator_Lam_Length, Skew=StatorSkewAngle, Slots=SlotNumber_Stator, SlotType=SlotType_Stator, Hs0=Hs0_Stator, Hs1=Hs1_Stator, Hs2=17.541151mm, Bs0=Bs0_Stator, Bs1=4.3148444mm, Bs2=6.61426mm, Rs=Rs_Stator, FilletType=FilletType_Stator, Layers=Layers, CoilPitch=5, EndExt=WdgExt_Avg, SpanExt=SpanExt, BendAngle=0deg, SegAngle=SegAngle_Coil_Armature, LenRegion=Model_Length, InfoCoil=1)
  Ph2_P1_C4_1.rotate(axis=Z, angle=60deg)
  Ph2_P2_C1_1 [Copper (Pure)_20C [ref. Temp]] = user_primitive(RMxprt/LapCoil.dll, DiaGap=132mm, DiaYoke=DiaStatorYoke, Length=Stator_Lam_Length, Skew=StatorSkewAngle, Slots=SlotNumber_Stator, SlotType=SlotType_Stator, Hs0=Hs0_Stator, Hs1=Hs1_Stator, Hs2=17.541151mm, Bs0=Bs0_Stator, Bs1=4.3148444mm, Bs2=6.61426mm, Rs=Rs_Stator, FilletType=FilletType_Stator, Layers=Layers, CoilPitch=5, EndExt=WdgExt_Avg, SpanExt=SpanExt, BendAngle=0deg, SegAngle=SegAngle_Coil_Armature, LenRegion=Model_Length, InfoCoil=1)
  Ph2_P2_C1_1.rotate(axis=Z, angle=15deg)
  Ph2_P2_C2_1 [Copper (Pure)_20C [ref. Temp]] = user_primitive(RMxprt/LapCoil.dll, DiaGap=132mm, DiaYoke=DiaStatorYoke, Length=Stator_Lam_Length, Skew=StatorSkewAngle, Slots=SlotNumber_Stator, SlotType=SlotType_Stator, Hs0=Hs0_Stator, Hs1=Hs1_Stator, Hs2=17.541151mm, Bs0=Bs0_Stator, Bs1=4.3148444mm, Bs2=6.61426mm, Rs=Rs_Stator, FilletType=FilletType_Stator, Layers=Layers, CoilPitch=5, EndExt=WdgExt_Avg, SpanExt=SpanExt, BendAngle=0deg, SegAngle=SegAngle_Coil_Armature, LenRegion=Model_Length, InfoCoil=1)
  Ph2_P2_C2_1.rotate(axis=Z, angle=330deg)
  Ph2_P2_C3_1 [Copper (Pure)_20C [ref. Temp]] = user_primitive(RMxprt/LapCoil.dll, DiaGap=132mm, DiaYoke=DiaStatorYoke, Length=Stator_Lam_Length, Skew=StatorSkewAngle, Slots=SlotNumber_Stator, SlotType=SlotType_Stator, Hs0=Hs0_Stator, Hs1=Hs1_Stator, Hs2=17.541151mm, Bs0=Bs0_Stator, Bs1=4.3148444mm, Bs2=6.61426mm, Rs=Rs_Stator, FilletType=FilletType_Stator, Layers=Layers, CoilPitch=5, EndExt=WdgExt_Avg, SpanExt=SpanExt, BendAngle=0deg, SegAngle=SegAngle_Coil_Armature, LenRegion=Model_Length, InfoCoil=1)
  Ph2_P2_C3_1.rotate(axis=Z, angle=285deg)
  Ph2_P2_C4_1 [Copper (Pure)_20C [ref. Temp]] = user_primitive(RMxprt/LapCoil.dll, DiaGap=132mm, DiaYoke=DiaStatorYoke, Length=Stator_Lam_Length, Skew=StatorSkewAngle, Slots=SlotNumber_Stator, SlotType=SlotType_Stator, Hs0=Hs0_Stator, Hs1=Hs1_Stator, Hs2=17.541151mm, Bs0=Bs0_Stator, Bs1=4.3148444mm, Bs2=6.61426mm, Rs=Rs_Stator, FilletType=FilletType_Stator, Layers=Layers, CoilPitch=5, EndExt=WdgExt_Avg, SpanExt=SpanExt, BendAngle=0deg, SegAngle=SegAngle_Coil_Armature, LenRegion=Model_Length, InfoCoil=1)
  Ph2_P2_C4_1.rotate(axis=Z, angle=240deg)
  Ph3_P1_C1_1 [Copper (Pure)_20C [ref. Temp]] = user_primitive(RMxprt/LapCoil.dll, DiaGap=132mm, DiaYoke=DiaStatorYoke, Length=Stator_Lam_Length, Skew=StatorSkewAngle, Slots=SlotNumber_Stator, SlotType=SlotType_Stator, Hs0=Hs0_Stator, Hs1=Hs1_Stator, Hs2=17.541151mm, Bs0=Bs0_Stator, Bs1=4.3148444mm, Bs2=6.61426mm, Rs=Rs_Stator, FilletType=FilletType_Stator, Layers=Layers, CoilPitch=5, EndExt=WdgExt_Avg, SpanExt=SpanExt, BendAngle=0deg, SegAngle=SegAngle_Coil_Armature, LenRegion=Model_Length, InfoCoil=1)
  Ph3_P1_C1_1.rotate(axis=Z, angle=75deg)
  Ph3_P1_C2_1 [Copper (Pure)_20C [ref. Temp]] = user_primitive(RMxprt/LapCoil.dll, DiaGap=132mm, DiaYoke=DiaStatorYoke, Length=Stator_Lam_Length, Skew=StatorSkewAngle, Slots=SlotNumber_Stator, SlotType=SlotType_Stator, Hs0=Hs0_Stator, Hs1=Hs1_Stator, Hs2=17.541151mm, Bs0=Bs0_Stator, Bs1=4.3148444mm, Bs2=6.61426mm, Rs=Rs_Stator, FilletType=FilletType_Stator, Layers=Layers, CoilPitch=5, EndExt=WdgExt_Avg, SpanExt=SpanExt, BendAngle=0deg, SegAngle=SegAngle_Coil_Armature, LenRegion=Model_Length, InfoCoil=1)
  Ph3_P1_C2_1.rotate(axis=Z, angle=30deg)
  Ph3_P1_C3_1 [Copper (Pure)_20C [ref. Temp]] = user_primitive(RMxprt/LapCoil.dll, DiaGap=132mm, DiaYoke=DiaStatorYoke, Length=Stator_Lam_Length, Skew=StatorSkewAngle, Slots=SlotNumber_Stator, SlotType=SlotType_Stator, Hs0=Hs0_Stator, Hs1=Hs1_Stator, Hs2=17.541151mm, Bs0=Bs0_Stator, Bs1=4.3148444mm, Bs2=6.61426mm, Rs=Rs_Stator, FilletType=FilletType_Stator, Layers=Layers, CoilPitch=5, EndExt=WdgExt_Avg, SpanExt=SpanExt, BendAngle=0deg, SegAngle=SegAngle_Coil_Armature, LenRegion=Model_Length, InfoCoil=1)
  Ph3_P1_C3_1.rotate(axis=Z, angle=345deg)
  Ph3_P1_C4_1 [Copper (Pure)_20C [ref. Temp]] = user_primitive(RMxprt/LapCoil.dll, DiaGap=132mm, DiaYoke=DiaStatorYoke, Length=Stator_Lam_Length, Skew=StatorSkewAngle, Slots=SlotNumber_Stator, SlotType=SlotType_Stator, Hs0=Hs0_Stator, Hs1=Hs1_Stator, Hs2=17.541151mm, Bs0=Bs0_Stator, Bs1=4.3148444mm, Bs2=6.61426mm, Rs=Rs_Stator, FilletType=FilletType_Stator, Layers=Layers, CoilPitch=5, EndExt=WdgExt_Avg, SpanExt=SpanExt, BendAngle=0deg, SegAngle=SegAngle_Coil_Armature, LenRegion=Model_Length, InfoCoil=1)
  Ph3_P1_C4_1.rotate(axis=Z, angle=300deg)
  Ph3_P2_C1_1 [Copper (Pure)_20C [ref. Temp]] = user_primitive(RMxprt/LapCoil.dll, DiaGap=132mm, DiaYoke=DiaStatorYoke, Length=Stator_Lam_Length, Skew=StatorSkewAngle, Slots=SlotNumber_Stator, SlotType=SlotType_Stator, Hs0=Hs0_Stator, Hs1=Hs1_Stator, Hs2=17.541151mm, Bs0=Bs0_Stator, Bs1=4.3148444mm, Bs2=6.61426mm, Rs=Rs_Stator, FilletType=FilletType_Stator, Layers=Layers, CoilPitch=5, EndExt=WdgExt_Avg, SpanExt=SpanExt, BendAngle=0deg, SegAngle=SegAngle_Coil_Armature, LenRegion=Model_Length, InfoCoil=1)
  Ph3_P2_C1_1.rotate(axis=Z, angle=255deg)
  Ph3_P2_C2_1 [Copper (Pure)_20C [ref. Temp]] = user_primitive(RMxprt/LapCoil.dll, DiaGap=132mm, DiaYoke=DiaStatorYoke, Length=Stator_Lam_Length, Skew=StatorSkewAngle, Slots=SlotNumber_Stator, SlotType=SlotType_Stator, Hs0=Hs0_Stator, Hs1=Hs1_Stator, Hs2=17.541151mm, Bs0=Bs0_Stator, Bs1=4.3148444mm, Bs2=6.61426mm, Rs=Rs_Stator, FilletType=FilletType_Stator, Layers=Layers, CoilPitch=5, EndExt=WdgExt_Avg, SpanExt=SpanExt, BendAngle=0deg, SegAngle=SegAngle_Coil_Armature, LenRegion=Model_Length, InfoCoil=1)
  Ph3_P2_C2_1.rotate(axis=Z, angle=210deg)
  Ph3_P2_C3_1 [Copper (Pure)_20C [ref. Temp]] = user_primitive(RMxprt/LapCoil.dll, DiaGap=132mm, DiaYoke=DiaStatorYoke, Length=Stator_Lam_Length, Skew=StatorSkewAngle, Slots=SlotNumber_Stator, SlotType=SlotType_Stator, Hs0=Hs0_Stator, Hs1=Hs1_Stator, Hs2=17.541151mm, Bs0=Bs0_Stator, Bs1=4.3148444mm, Bs2=6.61426mm, Rs=Rs_Stator, FilletType=FilletType_Stator, Layers=Layers, CoilPitch=5, EndExt=WdgExt_Avg, SpanExt=SpanExt, BendAngle=0deg, SegAngle=SegAngle_Coil_Armature, LenRegion=Model_Length, InfoCoil=1)
  Ph3_P2_C3_1.rotate(axis=Z, angle=165deg)
  Ph3_P2_C4_1 [Copper (Pure)_20C [ref. Temp]] = user_primitive(RMxprt/LapCoil.dll, DiaGap=132mm, DiaYoke=DiaStatorYoke, Length=Stator_Lam_Length, Skew=StatorSkewAngle, Slots=SlotNumber_Stator, SlotType=SlotType_Stator, Hs0=Hs0_Stator, Hs1=Hs1_Stator, Hs2=17.541151mm, Bs0=Bs0_Stator, Bs1=4.3148444mm, Bs2=6.61426mm, Rs=Rs_Stator, FilletType=FilletType_Stator, Layers=Layers, CoilPitch=5, EndExt=WdgExt_Avg, SpanExt=SpanExt, BendAngle=0deg, SegAngle=SegAngle_Coil_Armature, LenRegion=Model_Length, InfoCoil=1)
  Ph3_P2_C4_1.rotate(axis=Z, angle=120deg)
  Ph1_P1_C1_2 [Copper (Pure)_20C [ref. Temp]] = Ph1_P1_C1_1.separate_bodies()
  Ph1_P1_C2_2 [Copper (Pure)_20C [ref. Temp]] = Ph1_P1_C2_1.separate_bodies()
  Ph1_P1_C3_2 [Copper (Pure)_20C [ref. Temp]] = Ph1_P1_C3_1.separate_bodies()
  Ph1_P1_C4_2 [Copper (Pure)_20C [ref. Temp]] = Ph1_P1_C4_1.separate_bodies()
  Ph1_P2_C1_2 [Copper (Pure)_20C [ref. Temp]] = Ph1_P2_C1_1.separate_bodies()
  Ph1_P2_C2_2 [Copper (Pure)_20C [ref. Temp]] = Ph1_P2_C2_1.separate_bodies()
  Ph1_P2_C3_2 [Copper (Pure)_20C [ref. Temp]] = Ph1_P2_C3_1.separate_bodies()
  Ph1_P2_C4_2 [Copper (Pure)_20C [ref. Temp]] = Ph1_P2_C4_1.separate_bodies()
  Ph2_P1_C1_2 [Copper (Pure)_20C [ref. Temp]] = Ph2_P1_C1_1.separate_bodies()
  Ph2_P1_C2_2 [Copper (Pure)_20C [ref. Temp]] = Ph2_P1_C2_1.separate_bodies()
  Ph2_P1_C3_2 [Copper (Pure)_20C [ref. Temp]] = Ph2_P1_C3_1.separate_bodies()
  Ph2_P1_C4_2 [Copper (Pure)_20C [ref. Temp]] = Ph2_P1_C4_1.separate_bodies()
  Ph2_P2_C1_2 [Copper (Pure)_20C [ref. Temp]] = Ph2_P2_C1_1.separate_bodies()
  Ph2_P2_C2_2 [Copper (Pure)_20C [ref. Temp]] = Ph2_P2_C2_1.separate_bodies()
  Ph2_P2_C3_2 [Copper (Pure)_20C [ref. Temp]] = Ph2_P2_C3_1.separate_bodies()
  Ph2_P2_C4_2 [Copper (Pure)_20C [ref. Temp]] = Ph2_P2_C4_1.separate_bodies()
  Ph3_P1_C1_2 [Copper (Pure)_20C [ref. Temp]] = Ph3_P1_C1_1.separate_bodies()
  Ph3_P1_C2_2 [Copper (Pure)_20C [ref. Temp]] = Ph3_P1_C2_1.separate_bodies()
  Ph3_P1_C3_2 [Copper (Pure)_20C [ref. Temp]] = Ph3_P1_C3_1.separate_bodies()
  Ph3_P1_C4_2 [Copper (Pure)_20C [ref. Temp]] = Ph3_P1_C4_1.separate_bodies()
  Ph3_P2_C1_2 [Copper (Pure)_20C [ref. Temp]] = Ph3_P2_C1_1.separate_bodies()
  Ph3_P2_C2_2 [Copper (Pure)_20C [ref. Temp]] = Ph3_P2_C2_1.separate_bodies()
  Ph3_P2_C3_2 [Copper (Pure)_20C [ref. Temp]] = Ph3_P2_C3_1.separate_bodies()
  Ph3_P2_C4_2 [Copper (Pure)_20C [ref. Temp]] = Ph3_P2_C4_1.separate_bodies()
  Rotating_Band [vacuum] = user_primitive(RMxprt/Band.dll, DiaGap=DiaGap - (2 * (Airgap - Banding_Thickness)) + (4 * ((airgap - Banding_Thickness - Sleeve_Thickness) / 4)), DiaYoke=Shaft_Hole_Diameter, Length=0mm, SegAngle=0deg, Fractions=SymmetryFactor, HalfAxial=HalfAxial, InfoCore=0)
  Band_Tool = user_primitive(RMxprt/Band.dll, DiaGap=1mm, DiaYoke=DiaOuter, Length=0mm, SegAngle=SegAngle, Fractions=SymmetryFactor, HalfAxial=HalfAxial, InfoCore=1)
  Whole_Region [vacuum] = user_primitive(RMxprt/Band.dll, DiaGap=DiaGap+Airgap, DiaYoke=DiaOuter, Length=0mm, SegAngle=SegAngle, Fractions=SymmetryFactor, HalfAxial=HalfAxial, InfoCore=100)
  Band_Tool_1 = Band_Tool.copy()
  Stator_Lamination_Primitive.subtract(Band_Tool_1)
  Band_Tool_2 = Band_Tool.copy()
  Rotor_1.subtract(Band_Tool_2)
  Band_Tool_3 = Band_Tool.copy()
  Rotor_Pocket.subtract(Band_Tool_3)
  Band_Tool_4 = Band_Tool.copy()
  L1_1Magnet2S3_1.subtract(Band_Tool_4)
  Band_Tool_5 = Band_Tool.copy()
  Rotor_Pocket_1.subtract(Band_Tool_5)
  Band_Tool_6 = Band_Tool.copy()
  L1_1Magnet1N3_1.subtract(Band_Tool_6)
  Band_Tool_7 = Band_Tool.copy()
  Rotor_Pocket_2.subtract(Band_Tool_7)
  Band_Tool_8 = Band_Tool.copy()
  Rotor_Pocket_3.subtract(Band_Tool_8)
  Band_Tool_9 = Band_Tool.copy()
  Rotor_Pocket_4.subtract(Band_Tool_9)
  Band_Tool_10 = Band_Tool.copy()
  L1_1Magnet2N3_1.subtract(Band_Tool_10)
  Band_Tool_11 = Band_Tool.copy()
  Rotor_Pocket_5.subtract(Band_Tool_11)
  Band_Tool_12 = Band_Tool.copy()
  L1_1Magnet2N2_1.subtract(Band_Tool_12)
  Band_Tool_13 = Band_Tool.copy()
  Rotor_Pocket_6.subtract(Band_Tool_13)
  Band_Tool_14 = Band_Tool.copy()
  L1_1Magnet2S4_1.subtract(Band_Tool_14)
  Band_Tool_15 = Band_Tool.copy()
  Rotor_Pocket_7.subtract(Band_Tool_15)
  Band_Tool_16 = Band_Tool.copy()
  L1_1Magnet2S2_1.subtract(Band_Tool_16)
  Band_Tool_17 = Band_Tool.copy()
  Rotor_Pocket_8.subtract(Band_Tool_17)
  Band_Tool_18 = Band_Tool.copy()
  L1_1Magnet2N4_1.subtract(Band_Tool_18)
  Band_Tool_19 = Band_Tool.copy()
  Rotor_Pocket_9.subtract(Band_Tool_19)
  Band_Tool_20 = Band_Tool.copy()
  L1_1Magnet2N1_1.subtract(Band_Tool_20)
  Band_Tool_21 = Band_Tool.copy()
  Rotor_Pocket_10.subtract(Band_Tool_21)
  Band_Tool_22 = Band_Tool.copy()
  L1_1Magnet2S1_1.subtract(Band_Tool_22)
  Band_Tool_23 = Band_Tool.copy()
  Rotor_Pocket_11.subtract(Band_Tool_23)
  Band_Tool_24 = Band_Tool.copy()
  L1_1Magnet1S3_1.subtract(Band_Tool_24)
  Band_Tool_25 = Band_Tool.copy()
  Rotor_Pocket_12.subtract(Band_Tool_25)
  Band_Tool_26 = Band_Tool.copy()
  L1_1Magnet1S4_1.subtract(Band_Tool_26)
  Band_Tool_27 = Band_Tool.copy()
  Rotor_Pocket_13.subtract(Band_Tool_27)
  Band_Tool_28 = Band_Tool.copy()
  L1_1Magnet1N2_1.subtract(Band_Tool_28)
  Band_Tool_29 = Band_Tool.copy()
  Rotor_Pocket_14.subtract(Band_Tool_29)
  Band_Tool_30 = Band_Tool.copy()
  L1_1Magnet1N4_1.subtract(Band_Tool_30)
  Band_Tool_31 = Band_Tool.copy()
  Rotor_Pocket_15.subtract(Band_Tool_31)
  Band_Tool_32 = Band_Tool.copy()
  L1_1Magnet1S2_1.subtract(Band_Tool_32)
  Band_Tool_33 = Band_Tool.copy()
  Rotor_Pocket_16.subtract(Band_Tool_33)
  Band_Tool_34 = Band_Tool.copy()
  L1_1Magnet1S1_1.subtract(Band_Tool_34)
  Band_Tool_35 = Band_Tool.copy()
  Rotor_Pocket_17.subtract(Band_Tool_35)
  Band_Tool_36 = Band_Tool.copy()
  L1_1Magnet1N1_1.subtract(Band_Tool_36)
  Band_Tool_37 = Band_Tool.copy()
  Rotor_Pocket_18.subtract(Band_Tool_37)
  Band_Tool_38 = Band_Tool.copy()
  Rotor_Pocket_19.subtract(Band_Tool_38)
  Band_Tool_39 = Band_Tool.copy()
  Rotor_Pocket_20.subtract(Band_Tool_39)
  Band_Tool_40 = Band_Tool.copy()
  Rotor_Pocket_21.subtract(Band_Tool_40)
  Band_Tool_41 = Band_Tool.copy()
  Rotor_Pocket_22.subtract(Band_Tool_41)
  Band_Tool_42 = Band_Tool.copy()
  Rotor_Pocket_23.subtract(Band_Tool_42)
  Band_Tool_43 = Band_Tool.copy()
  Rotor_Pocket_24.subtract(Band_Tool_43)
  Band_Tool_44 = Band_Tool.copy()
  Rotor_Pocket_25.subtract(Band_Tool_44)
  Band_Tool_45 = Band_Tool.copy()
  Rotor_Pocket_26.subtract(Band_Tool_45)
  Band_Tool_46 = Band_Tool.copy()
  Rotor_Pocket_27.subtract(Band_Tool_46)
  Band_Tool_47 = Band_Tool.copy()
  Rotor_Pocket_28.subtract(Band_Tool_47)
  Band_Tool_48 = Band_Tool.copy()
  Rotor_Pocket_29.subtract(Band_Tool_48)
  Band_Tool_49 = Band_Tool.copy()
  Rotor_Pocket_30.subtract(Band_Tool_49)
  Band_Tool_50 = Band_Tool.copy()
  Rotor_Pocket_31.subtract(Band_Tool_50)
  Band_Tool_51 = Band_Tool.copy()
  Shaft.subtract(Band_Tool_51)
  Band_Tool_52 = Band_Tool.copy()
  Ph1_P1_C1_1.subtract(Band_Tool_52)
  Band_Tool_53 = Band_Tool.copy()
  Ph1_P1_C2_1.subtract(Band_Tool_53)
  Band_Tool_54 = Band_Tool.copy()
  Ph1_P1_C3_1.subtract(Band_Tool_54)
  Band_Tool_55 = Band_Tool.copy()
  Ph1_P1_C4_1.subtract(Band_Tool_55)
  Band_Tool_56 = Band_Tool.copy()
  Ph1_P2_C1_1.subtract(Band_Tool_56)
  Band_Tool_57 = Band_Tool.copy()
  Ph1_P2_C2_1.subtract(Band_Tool_57)
  Band_Tool_58 = Band_Tool.copy()
  Ph1_P2_C3_1.subtract(Band_Tool_58)
  Band_Tool_59 = Band_Tool.copy()
  Ph1_P2_C4_1.subtract(Band_Tool_59)
  Band_Tool_60 = Band_Tool.copy()
  Ph2_P1_C1_1.subtract(Band_Tool_60)
  Band_Tool_61 = Band_Tool.copy()
  Ph2_P1_C2_1.subtract(Band_Tool_61)
  Band_Tool_62 = Band_Tool.copy()
  Ph2_P1_C3_1.subtract(Band_Tool_62)
  Band_Tool_63 = Band_Tool.copy()
  Ph2_P1_C4_1.subtract(Band_Tool_63)
  Band_Tool_64 = Band_Tool.copy()
  Ph2_P2_C1_1.subtract(Band_Tool_64)
  Band_Tool_65 = Band_Tool.copy()
  Ph2_P2_C2_1.subtract(Band_Tool_65)
  Band_Tool_66 = Band_Tool.copy()
  Ph2_P2_C3_1.subtract(Band_Tool_66)
  Band_Tool_67 = Band_Tool.copy()
  Ph2_P2_C4_1.subtract(Band_Tool_67)
  Band_Tool_68 = Band_Tool.copy()
  Ph3_P1_C1_1.subtract(Band_Tool_68)
  Band_Tool_69 = Band_Tool.copy()
  Ph3_P1_C2_1.subtract(Band_Tool_69)
  Band_Tool_70 = Band_Tool.copy()
  Ph3_P1_C3_1.subtract(Band_Tool_70)
  Band_Tool_71 = Band_Tool.copy()
  Ph3_P1_C4_1.subtract(Band_Tool_71)
  Band_Tool_72 = Band_Tool.copy()
  Ph3_P2_C1_1.subtract(Band_Tool_72)
  Band_Tool_73 = Band_Tool.copy()
  Ph3_P2_C2_1.subtract(Band_Tool_73)
  Band_Tool_74 = Band_Tool.copy()
  Ph3_P2_C3_1.subtract(Band_Tool_74)
  Band_Tool_75 = Band_Tool.copy()
  Ph3_P2_C4_1.subtract(Band_Tool_75)
  Band_Tool_76 = Band_Tool.copy()
  Ph1_P1_C1_2.subtract(Band_Tool_76)
  Band_Tool_77 = Band_Tool.copy()
  Ph1_P1_C2_2.subtract(Band_Tool_77)
  Band_Tool_78 = Band_Tool.copy()
  Ph1_P1_C3_2.subtract(Band_Tool_78)
  Band_Tool_79 = Band_Tool.copy()
  Ph1_P1_C4_2.subtract(Band_Tool_79)
  Band_Tool_80 = Band_Tool.copy()
  Ph1_P2_C1_2.subtract(Band_Tool_80)
  Band_Tool_81 = Band_Tool.copy()
  Ph1_P2_C2_2.subtract(Band_Tool_81)
  Band_Tool_82 = Band_Tool.copy()
  Ph1_P2_C3_2.subtract(Band_Tool_82)
  Band_Tool_83 = Band_Tool.copy()
  Ph1_P2_C4_2.subtract(Band_Tool_83)
  Band_Tool_84 = Band_Tool.copy()
  Ph2_P1_C1_2.subtract(Band_Tool_84)
  Band_Tool_85 = Band_Tool.copy()
  Ph2_P1_C2_2.subtract(Band_Tool_85)
  Band_Tool_86 = Band_Tool.copy()
  Ph2_P1_C3_2.subtract(Band_Tool_86)
  Band_Tool_87 = Band_Tool.copy()
  Ph2_P1_C4_2.subtract(Band_Tool_87)
  Band_Tool_88 = Band_Tool.copy()
  Ph2_P2_C1_2.subtract(Band_Tool_88)
  Band_Tool_89 = Band_Tool.copy()
  Ph2_P2_C2_2.subtract(Band_Tool_89)
  Band_Tool_90 = Band_Tool.copy()
  Ph2_P2_C3_2.subtract(Band_Tool_90)
  Band_Tool_91 = Band_Tool.copy()
  Ph2_P2_C4_2.subtract(Band_Tool_91)
  Band_Tool_92 = Band_Tool.copy()
  Ph3_P1_C1_2.subtract(Band_Tool_92)
  Band_Tool_93 = Band_Tool.copy()
  Ph3_P1_C2_2.subtract(Band_Tool_93)
  Band_Tool_94 = Band_Tool.copy()
  Ph3_P1_C3_2.subtract(Band_Tool_94)
  Band_Tool_95 = Band_Tool.copy()
  Ph3_P1_C4_2.subtract(Band_Tool_95)
  Band_Tool_96 = Band_Tool.copy()
  Ph3_P2_C1_2.subtract(Band_Tool_96)
  Band_Tool_97 = Band_Tool.copy()
  Ph3_P2_C2_2.subtract(Band_Tool_97)
  Band_Tool_98 = Band_Tool.copy()
  Ph3_P2_C3_2.subtract(Band_Tool_98)
  Band_Tool_99 = Band_Tool.copy()
  Ph3_P2_C4_2.subtract(Band_Tool_99)
  Rotating_Band.subtract(Band_Tool)
motion:
  MotionSetup1: Band Move_Type=Rotate Coordinate_System=Global Axis=Z Is_Positive=true InitPos=InitialPositionMD Angular_Velocity=-MachineRPM Objects=Rotating_Band
  Moving1: Moving Objects=[Rotor_1, Rotor_Pocket, L1_1Magnet2S3_1, Rotor_Pocket_1, L1_1Magnet1N3_1, Rotor_Pocket_2, Rotor_Pocket_3, Rotor_Pocket_4, L1_1Magnet2N3_1, Rotor_Pocket_5, L1_1Magnet2N2_1, Rotor_Pocket_6, L1_1Magnet2S4_1, Rotor_Pocket_7, L1_1Magnet2S2_1, Rotor_Pocket_8, L1_1Magnet2N4_1, Rotor_Pocket_9, L1_1Magnet2N1_1, Rotor_Pocket_10, L1_1Magnet2S1_1, Rotor_Pocket_11, L1_1Magnet1S3_1, Rotor_Pocket_12, L1_1Magnet1S4_1, Rotor_Pocket_13, L1_1Magnet1N2_1, Rotor_Pocket_14, L1_1Magnet1N4_1, Rotor_Pocket_15, L1_1Magnet1S2_1, Rotor_Pocket_16, L1_1Magnet1S1_1, Rotor_Pocket_17, L1_1Magnet1N1_1, Rotor_Pocket_18..Rotor_Pocket_31, Shaft]
boundaries and excitations:
  VectorPotential1: Vector Potential Edges=Whole_Region.edge(at (0, -99, 0)) Value=0
  CT_Ph1_P1_C1_Ret: Coil Objects=Ph1_P1_C1_1 Conductor_number=6 Winding=WG_Ph1_P1 PolarityType=Negative
  CT_Ph1_P1_C1_Go: Coil Objects=Ph1_P1_C1_2 Conductor_number=6 Winding=WG_Ph1_P1 PolarityType=Positive
  CT_Ph1_P1_C2_Go: Coil Objects=Ph1_P1_C2_1 Conductor_number=6 Winding=WG_Ph1_P1 PolarityType=Positive
  CT_Ph1_P1_C2_Ret: Coil Objects=Ph1_P1_C2_2 Conductor_number=6 Winding=WG_Ph1_P1 PolarityType=Negative
  CT_Ph1_P1_C3_Ret: Coil Objects=Ph1_P1_C3_1 Conductor_number=6 Winding=WG_Ph1_P1 PolarityType=Negative
  CT_Ph1_P1_C3_Go: Coil Objects=Ph1_P1_C3_2 Conductor_number=6 Winding=WG_Ph1_P1 PolarityType=Positive
  CT_Ph1_P1_C4_Go: Coil Objects=Ph1_P1_C4_1 Conductor_number=6 Winding=WG_Ph1_P1 PolarityType=Positive
  CT_Ph1_P1_C4_Ret: Coil Objects=Ph1_P1_C4_2 Conductor_number=6 Winding=WG_Ph1_P1 PolarityType=Negative
  CT_Ph1_P2_C1_Ret: Coil Objects=Ph1_P2_C1_1 Conductor_number=6 Winding=WG_Ph1_P1 PolarityType=Negative
  CT_Ph1_P2_C1_Go: Coil Objects=Ph1_P2_C1_2 Conductor_number=6 Winding=WG_Ph1_P1 PolarityType=Positive
  CT_Ph1_P2_C2_Go: Coil Objects=Ph1_P2_C2_1 Conductor_number=6 Winding=WG_Ph1_P1 PolarityType=Positive
  CT_Ph1_P2_C2_Ret: Coil Objects=Ph1_P2_C2_2 Conductor_number=6 Winding=WG_Ph1_P1 PolarityType=Negative
  CT_Ph1_P2_C3_Ret: Coil Objects=Ph1_P2_C3_1 Conductor_number=6 Winding=WG_Ph1_P1 PolarityType=Negative
  CT_Ph1_P2_C3_Go: Coil Objects=Ph1_P2_C3_2 Conductor_number=6 Winding=WG_Ph1_P1 PolarityType=Positive
  CT_Ph1_P2_C4_Go: Coil Objects=Ph1_P2_C4_1 Conductor_number=6 Winding=WG_Ph1_P1 PolarityType=Positive
  CT_Ph1_P2_C4_Ret: Coil Objects=Ph1_P2_C4_2 Conductor_number=6 Winding=WG_Ph1_P1 PolarityType=Negative
  CT_Ph2_P1_C1_Ret: Coil Objects=Ph2_P1_C1_1 Conductor_number=6 Winding=WG_Ph2_P1 PolarityType=Negative
  CT_Ph2_P1_C1_Go: Coil Objects=Ph2_P1_C1_2 Conductor_number=6 Winding=WG_Ph2_P1 PolarityType=Positive
  CT_Ph2_P1_C2_Go: Coil Objects=Ph2_P1_C2_1 Conductor_number=6 Winding=WG_Ph2_P1 PolarityType=Positive
  CT_Ph2_P1_C2_Ret: Coil Objects=Ph2_P1_C2_2 Conductor_number=6 Winding=WG_Ph2_P1 PolarityType=Negative
  CT_Ph2_P1_C3_Ret: Coil Objects=Ph2_P1_C3_1 Conductor_number=6 Winding=WG_Ph2_P1 PolarityType=Negative
  CT_Ph2_P1_C3_Go: Coil Objects=Ph2_P1_C3_2 Conductor_number=6 Winding=WG_Ph2_P1 PolarityType=Positive
  CT_Ph2_P1_C4_Go: Coil Objects=Ph2_P1_C4_1 Conductor_number=6 Winding=WG_Ph2_P1 PolarityType=Positive
  CT_Ph2_P1_C4_Ret: Coil Objects=Ph2_P1_C4_2 Conductor_number=6 Winding=WG_Ph2_P1 PolarityType=Negative
  CT_Ph2_P2_C1_Ret: Coil Objects=Ph2_P2_C1_1 Conductor_number=6 Winding=WG_Ph2_P1 PolarityType=Negative
  CT_Ph2_P2_C1_Go: Coil Objects=Ph2_P2_C1_2 Conductor_number=6 Winding=WG_Ph2_P1 PolarityType=Positive
  CT_Ph2_P2_C2_Go: Coil Objects=Ph2_P2_C2_1 Conductor_number=6 Winding=WG_Ph2_P1 PolarityType=Positive
  CT_Ph2_P2_C2_Ret: Coil Objects=Ph2_P2_C2_2 Conductor_number=6 Winding=WG_Ph2_P1 PolarityType=Negative
  CT_Ph2_P2_C3_Ret: Coil Objects=Ph2_P2_C3_1 Conductor_number=6 Winding=WG_Ph2_P1 PolarityType=Negative
  CT_Ph2_P2_C3_Go: Coil Objects=Ph2_P2_C3_2 Conductor_number=6 Winding=WG_Ph2_P1 PolarityType=Positive
  CT_Ph2_P2_C4_Go: Coil Objects=Ph2_P2_C4_1 Conductor_number=6 Winding=WG_Ph2_P1 PolarityType=Positive
  CT_Ph2_P2_C4_Ret: Coil Objects=Ph2_P2_C4_2 Conductor_number=6 Winding=WG_Ph2_P1 PolarityType=Negative
  CT_Ph3_P1_C1_Ret: Coil Objects=Ph3_P1_C1_1 Conductor_number=6 Winding=WG_Ph3_P1 PolarityType=Negative
  CT_Ph3_P1_C1_Go: Coil Objects=Ph3_P1_C1_2 Conductor_number=6 Winding=WG_Ph3_P1 PolarityType=Positive
  CT_Ph3_P1_C2_Go: Coil Objects=Ph3_P1_C2_1 Conductor_number=6 Winding=WG_Ph3_P1 PolarityType=Positive
  CT_Ph3_P1_C2_Ret: Coil Objects=Ph3_P1_C2_2 Conductor_number=6 Winding=WG_Ph3_P1 PolarityType=Negative
  CT_Ph3_P1_C3_Ret: Coil Objects=Ph3_P1_C3_1 Conductor_number=6 Winding=WG_Ph3_P1 PolarityType=Negative
  CT_Ph3_P1_C3_Go: Coil Objects=Ph3_P1_C3_2 Conductor_number=6 Winding=WG_Ph3_P1 PolarityType=Positive
  CT_Ph3_P1_C4_Go: Coil Objects=Ph3_P1_C4_1 Conductor_number=6 Winding=WG_Ph3_P1 PolarityType=Positive
  CT_Ph3_P1_C4_Ret: Coil Objects=Ph3_P1_C4_2 Conductor_number=6 Winding=WG_Ph3_P1 PolarityType=Negative
  CT_Ph3_P2_C1_Ret: Coil Objects=Ph3_P2_C1_1 Conductor_number=6 Winding=WG_Ph3_P1 PolarityType=Negative
  CT_Ph3_P2_C1_Go: Coil Objects=Ph3_P2_C1_2 Conductor_number=6 Winding=WG_Ph3_P1 PolarityType=Positive
  CT_Ph3_P2_C2_Go: Coil Objects=Ph3_P2_C2_1 Conductor_number=6 Winding=WG_Ph3_P1 PolarityType=Positive
  CT_Ph3_P2_C2_Ret: Coil Objects=Ph3_P2_C2_2 Conductor_number=6 Winding=WG_Ph3_P1 PolarityType=Negative
  CT_Ph3_P2_C3_Ret: Coil Objects=Ph3_P2_C3_1 Conductor_number=6 Winding=WG_Ph3_P1 PolarityType=Negative
  CT_Ph3_P2_C3_Go: Coil Objects=Ph3_P2_C3_2 Conductor_number=6 Winding=WG_Ph3_P1 PolarityType=Positive
  CT_Ph3_P2_C4_Go: Coil Objects=Ph3_P2_C4_1 Conductor_number=6 Winding=WG_Ph3_P1 PolarityType=Positive
  CT_Ph3_P2_C4_Ret: Coil Objects=Ph3_P2_C4_2 Conductor_number=6 Winding=WG_Ph3_P1 PolarityType=Negative
  L1_1Magnet2S3_1: Current Objects=L1_1Magnet2S3_1 Current=0A IsSolid=true IsPositive=true
  L1_1Magnet2N3_1: Current Objects=L1_1Magnet2N3_1 Current=0A IsSolid=true IsPositive=true
  L1_1Magnet2N2_1: Current Objects=L1_1Magnet2N2_1 Current=0A IsSolid=true IsPositive=true
  L1_1Magnet2S4_1: Current Objects=L1_1Magnet2S4_1 Current=0A IsSolid=true IsPositive=true
  L1_1Magnet2S2_1: Current Objects=L1_1Magnet2S2_1 Current=0A IsSolid=true IsPositive=true
  L1_1Magnet2N4_1: Current Objects=L1_1Magnet2N4_1 Current=0A IsSolid=true IsPositive=true
  L1_1Magnet2N1_1: Current Objects=L1_1Magnet2N1_1 Current=0A IsSolid=true IsPositive=true
  L1_1Magnet2S1_1: Current Objects=L1_1Magnet2S1_1 Current=0A IsSolid=true IsPositive=true
  L1_1Magnet1N3_1: Current Objects=L1_1Magnet1N3_1 Current=0A IsSolid=true IsPositive=true
  L1_1Magnet1S3_1: Current Objects=L1_1Magnet1S3_1 Current=0A IsSolid=true IsPositive=true
  L1_1Magnet1S4_1: Current Objects=L1_1Magnet1S4_1 Current=0A IsSolid=true IsPositive=true
  L1_1Magnet1N2_1: Current Objects=L1_1Magnet1N2_1 Current=0A IsSolid=true IsPositive=true
  L1_1Magnet1N4_1: Current Objects=L1_1Magnet1N4_1 Current=0A IsSolid=true IsPositive=true
  L1_1Magnet1S2_1: Current Objects=L1_1Magnet1S2_1 Current=0A IsSolid=true IsPositive=true
  L1_1Magnet1S1_1: Current Objects=L1_1Magnet1S1_1 Current=0A IsSolid=true IsPositive=true
  L1_1Magnet1N1_1: Current Objects=L1_1Magnet1N1_1 Current=0A IsSolid=true IsPositive=true
  WG_Ph1_P1: Winding Group Type=External IsSolid=false Current="IPeak * sin((pi * MachineRPM/1rpm*NumPoles / 60*time + (360 - 0) / 360 * 2 * pi) + PhaseAdvance )" ParallelBranchesNum=ParallelPaths
  WG_Ph2_P1: Winding Group Type=External IsSolid=false Current="IPeak * sin((pi * MachineRPM/1rpm*NumPoles / 60*time + (360 - 120) / 360 * 2 * pi) + PhaseAdvance )" ParallelBranchesNum=ParallelPaths
  WG_Ph3_P1: Winding Group Type=External IsSolid=false Current="IPeak * sin((pi * MachineRPM/1rpm*NumPoles / 60*time + (360 - 240) / 360 * 2 * pi) + PhaseAdvance )" ParallelBranchesNum=ParallelPaths
  eddy effects on: L1_1Magnet2S3_1, L1_1Magnet1N3_1, L1_1Magnet2N3_1, L1_1Magnet2N2_1, L1_1Magnet2S4_1, L1_1Magnet2S2_1, L1_1Magnet2N4_1, L1_1Magnet2N1_1, L1_1Magnet2S1_1, L1_1Magnet1S3_1, L1_1Magnet1S4_1, L1_1Magnet1N2_1, L1_1Magnet1N4_1, L1_1Magnet1S2_1, L1_1Magnet1S1_1, L1_1Magnet1N1_1
  core loss on: Stator_Lamination_Primitive, Rotor_1
  external circuit: ".MODEL ECE_Model1_Full360_PMSM_Healthy_ECE3 ECE3 (Windings=WG_Ph1_P1,WG_Ph2_P1,WG_Ph3_P1 Sweeps=0A,21.65A,43.3A,108.25A,216.5A,324.75A,433A PAngN=2 Res=0.0133773639742649ohm Ind=6.02692576178796e-06H)\"
mesh:
  CylindricalGap1: CylindricalGap Objects=Rotating_Band BandMappingAngle="(360/720) deg" Objects=Rotating_Band
temperatures:
  Stator_Lamination_Primitive, Rotor_1, Rotor_Pocket, Rotor_Pocket_1..Rotor_Pocket_31, Shaft, Ph1_P1_C1_1, Ph1_P1_C2_1, Ph1_P1_C3_1, Ph1_P1_C4_1, Ph1_P2_C1_1, Ph1_P2_C2_1, Ph1_P2_C3_1, Ph1_P2_C4_1, Ph2_P1_C1_1, Ph2_P1_C2_1, Ph2_P1_C3_1, Ph2_P1_C4_1, Ph2_P2_C1_1, Ph2_P2_C2_1, Ph2_P2_C3_1, Ph2_P2_C4_1, Ph3_P1_C1_1, Ph3_P1_C2_1, Ph3_P1_C3_1, Ph3_P1_C4_1, Ph3_P2_C1_1, Ph3_P2_C2_1, Ph3_P2_C3_1, Ph3_P2_C4_1, Ph1_P1_C1_2, Ph1_P1_C2_2, Ph1_P1_C3_2, Ph1_P1_C4_2, Ph1_P2_C1_2, Ph1_P2_C2_2, Ph1_P2_C3_2, Ph1_P2_C4_2, Ph2_P1_C1_2, Ph2_P1_C2_2, Ph2_P1_C3_2, Ph2_P1_C4_2, Ph2_P2_C1_2, Ph2_P2_C2_2, Ph2_P2_C3_2, Ph2_P2_C4_2, Ph3_P1_C1_2, Ph3_P1_C2_2, Ph3_P1_C3_2, Ph3_P1_C4_2, Ph3_P2_C1_2, Ph3_P2_C2_2, Ph3_P2_C3_2, Ph3_P2_C4_2, Rotating_Band, Whole_Region: 22cel
  L1_1Magnet2S3_1, L1_1Magnet1N3_1, L1_1Magnet2N3_1, L1_1Magnet2N2_1, L1_1Magnet2S4_1, L1_1Magnet2S2_1, L1_1Magnet2N4_1, L1_1Magnet2N1_1, L1_1Magnet2S1_1, L1_1Magnet1S3_1, L1_1Magnet1S4_1, L1_1Magnet1N2_1, L1_1Magnet1N4_1, L1_1Magnet1S2_1, L1_1Magnet1S1_1, L1_1Magnet1N1_1: 65cel
setups:
  Setup1: Transient NonlinearSolverResidual=0.0001 ScalarPotential="Second Order" StopTime="NumTorqueCycles*120/(MachineRPM/1rpm*NumPoles) s" TimeStep="120/(MachineRPM/1rpm*NumPoles)/NumTorquePointsPerCycle s" OutputPerObjectCoreLoss OutputPerObjectSolidLoss InitialTimeStep="120/(MachineRPM/1rpm*NumPoles)/NumTorquePointsPerCycle s" MinTimeStep=0.001s MaxTimeStep=0.003s TimeStepErrTolerance=0.0001
  Setup2: Transient NonlinearSolverResidual=0.0001 ScalarPotential="Second Order" StopTime=25ms TimeStep=12.5us InitialTimeStep=0.002s MinTimeStep=0.001s MaxTimeStep=0.003s TimeStepErrTolerance=0.0001
output variables:
  ThetaED = ((pi * MachineRPM/1rpm*NumPoles / 60*time + (360 - 0) / 360 * 2 * pi)) + pi
  Id_peak = 2/3*(InputCurrent(WG_Ph1_P1)*cos(ThetaED + 360deg)+InputCurrent(WG_Ph2_P1)*cos(ThetaED + 240deg)+InputCurrent(WG_Ph3_P1)*cos(ThetaED + 120deg))
  Iq_peak = 2/3*(InputCurrent(WG_Ph1_P1)*-sin(ThetaED + 360deg)+InputCurrent(WG_Ph2_P1)*-sin(ThetaED + 240deg)+InputCurrent(WG_Ph3_P1)*-sin(ThetaED + 120deg))
  PsiD = 2/3*(FluxLinkage(WG_Ph1_P1)*cos(ThetaED + 360deg)+FluxLinkage(WG_Ph2_P1)*cos(ThetaED + 240deg)+FluxLinkage(WG_Ph3_P1)*cos(ThetaED + 120deg))
  PsiQ = 2/3*(FluxLinkage(WG_Ph1_P1)*-sin(ThetaED + 360deg)+FluxLinkage(WG_Ph2_P1)*-sin(ThetaED + 240deg)+FluxLinkage(WG_Ph3_P1)*-sin(ThetaED + 120deg))
  TorqueDQ = 3/2*NumPoles/2*(PsiD*Iq_peak - PsiQ*Id_peak)
reports:
  Induced Voltage Plots: InducedVoltage(WG_Ph1_P1), InducedVoltage(WG_Ph2_P1), InducedVoltage(WG_Ph3_P1) vs Time on Setup1 : Transient
  Drive Current Plots: InputCurrent(WG_Ph1_P1), InputCurrent(WG_Ph2_P1), InputCurrent(WG_Ph3_P1), Id_peak, Iq_peak vs Time on Setup1 : Transient
  Flux Linkage Plots: FluxLinkage(WG_Ph1_P1), FluxLinkage(WG_Ph2_P1), FluxLinkage(WG_Ph3_P1), PsiD, PsiQ vs Time on Setup1 : Transient
  Torque Plots: -Moving1.Torque, TorqueDQ vs Time on Setup1 : Transient
  setup2_InducedVoltage: InducedVoltage(WG_Ph1_P1), InducedVoltage(WG_Ph2_P1), InducedVoltage(WG_Ph3_P1) vs Time on Setup2 : Transient
  setup2_Drive Current Plots: InputCurrent(WG_Ph1_P1), InputCurrent(WG_Ph2_P1), InputCurrent(WG_Ph3_P1), Id_peak, Iq_peak vs Time on Setup2 : Transient

design PMSM_UD (Maxwell 2D, Transient, XY geometry, model units mm)
options: ModelDepth=Magnetic_Axial_Length EnableTranTranLinkWithSimplorer
variables:
  Is_2D_Design = 1
  DiaGap = 132mm
  DiaStatorYoke = 198mm
  DiaShaft = 80mm
  DiaShaft_Effective = 80mm
  DiaOuter = 198mm
  Airgap = 1mm
  StatorSkewAngle = 0deg
  Model_Length = 0mm
  Magnet_Length = 150mm
  Stator_Lam_Length = 0mm
  Rotor_Lam_Length = 0mm
  RotorDia = 130mm
  Rotor_Slices = 1
  SlotNumber_Stator = 48
  SlotType_Stator = 3
  Hs0_Stator = 1mm
  Hs1_Stator = 0.33497334mm
  Hs2_Stator = 17.541151mm
  Bs0_Stator = 3mm
  Bs1_Stator = 4.3148444mm
  Bs2_Stator = 6.61426mm
  Rs_Stator = 2mm
  FilletType_Stator = 3
  Magnetic_Axial_Length = 150mm
  Layers = 1
  ParallelPaths = 2
  SpanExt = 25.214884mm
  WdgExt_Avg = 5mm
  HalfAxial = 0
  SymmetryFactor = 1
  SegAngle = 0deg
  SegAngle_Coil_Armature = 10deg
  NumPoles = 8
  Magnet_Axial_Offset = 0mm
  Axial_Segments = 18
  PoleType_VPMCore = 1
  L1_ThicknessDuct = 6.2mm
  L1_WidthDuct = 17mm
  L1_ThicknessBridge = 1mm
  L1_ExtOuter = 2mm
  L1_ExtInner = 2mm
  L1_PoleVAngle = 150deg
  L1_ArcPole = 155deg
  L1_ThicknessPost = 0.5mm
  L1_DminMag = 4.5631061mm
  L1_WidthMagnet = 16mm
  L1_InnerGapMagnet = 0.2mm
  Shaft_Hole_Diameter = 0mm
  Sleeve_Thickness = 0mm
  Banding_Thickness = 0mm
  IPeak = 433A
  PhaseAdvance = 65.79deg
  MachineRPM = 6000rpm
  Vpeak = 405.78194V
  Rphase = 0.013377364ohm
  PhasorAngle = 29.390739deg
  MaxPhasorAngle = 120deg
  PeakDriveVoltage = Vpeak / (2*sin(MaxPhasorAngle / 2))
  Lend = 6.0269258e-06H
  NumTorqueCycles = 1
  NumTorquePointsPerCycle = 30
  DriveOffsetED = 0deg
  InitialPositionMD = -DriveOffsetED / (NumPoles/2)
geometry:
  Stator_Lamination_Primitive [M250-35A_20C_SF0.97] = user_primitive(RMxprt/VentSlotCore.dll, DiaGap=DiaGap, DiaYoke=DiaStatorYoke, Length=Stator_Lam_Length, Skew=StatorSkewAngle, Slots=SlotNumber_Stator, SlotType=SlotType_Stator, Hs0=Hs0_Stator, Hs01=0mm, Hs1=Hs1_Stator, Hs2=17.541151mm, Bs0=Bs0_Stator, Bs1=4.3148444mm, Bs2=6.61426mm, Rs=Rs_Stator, FilletType=FilletType_Stator, HalfSlot=0, VentHoles=0, HoleDiaIn=0mm, HoleDiaOut=0mm, HoleLocIn=0mm, HoleLocOut=0mm, VentDucts=0, DuctWidth=0mm, DuctPitch=0mm, SegAngle=SegAngle, LenRegion=0mm, InfoCore=0)
  Rotor_1 [M250-35A_20C_SF0.97] = circle(normal=Z, centre=(0mm, 0mm, 0mm), radius=65mm)
  Rotor_Subtract_6 = circle(normal=Z, centre=(0mm, 0mm, 0mm), radius=40mm)
  Rotor_1.subtract(Rotor_Subtract_6)
  Rotor_Pocket [vacuum] = polyline(z=0mm, xy in mm: (-63.2908, 7.3463) (-63.5952, 6.9496) (-62.3533, 3.4757) (-58.6764, 3.1753) (-58.372, 3.572) (-48.6318, 16.2656) (-48.3274, 16.6623) (-49.5693, 20.1362) (-53.2462, 20.4366) (-53.5506, 20.0399) (-63.2908, 7.3463), closed, covered, Arc from point 1 over 3, Arc from point 6 over 3)
  coordinate_system CS_L1_1Magnet2S3_1 = origin=(-56.04069mm, 11.866879mm, 0mm) x=(0.84432629mm, -0.64787435mm, 0mm) y=(0.64787435mm, 0.84432629mm, 0mm)
  L1_1Magnet2S3_1 [N30UH_20C [ref. Temp]_2D3DFactMagnet, oriented by CS_L1_1Magnet2S3_1] = polyline(z=0mm, xy in mm: (-63.2908, 7.3463) (-58.5307, 3.6937) (-48.7905, 16.3874) (-53.5506, 20.0399) (-63.2908, 7.3463), closed, covered)
  Rotor_Pocket_1 [vacuum] = polyline(z=0mm, xy in mm: (-63.5952, -6.9496) (-63.2908, -7.3463) (-53.5506, -20.0399) (-53.2462, -20.4366) (-49.5693, -20.1362) (-48.3274, -16.6623) (-48.6318, -16.2656) (-58.372, -3.572) (-58.6764, -3.1753) (-62.3533, -3.4757) (-63.5952, -6.9496), closed, covered, Arc from point 3 over 3, Arc from point 8 over 3)
  coordinate_system CS_L1_1Magnet1N3_1 = origin=(-56.04069mm, -11.866879mm, 0mm) x=(-0.84432629mm, -0.64787435mm, 0mm) y=(0.64787435mm, -0.84432629mm, 0mm)
  L1_1Magnet1N3_1 [N30UH_20C [ref. Temp]_2D3DFactMagnet, oriented by CS_L1_1Magnet1N3_1] = polyline(z=0mm, xy in mm: (-58.5307, -3.6937) (-63.2908, -7.3463) (-53.5506, -20.0399) (-48.7905, -16.3874) (-58.5307, -3.6937), closed, covered)
  Rotor_Pocket_2 [vacuum] = polyline(z=0mm, xy in mm: (-63.0692, 15.7249) (-61.7463, 16.8339) (-62.3232, 18.4609) (-62.7111, 17.097) (-63.0692, 15.7249), closed, covered, Arc from point 2 over 3)
  Rotor_Pocket_3 [vacuum] = polyline(z=0mm, xy in mm: (-63.0692, -15.7249) (-62.7111, -17.097) (-62.3232, -18.4609) (-61.7463, -16.8339) (-63.0692, -15.7249), closed, covered, Arc from point 0 over 3)
  Rotor_Pocket_4 [vacuum] = polyline(z=0mm, xy in mm: (-52.1017, -23.1998) (-52.0364, -23.6956) (-49.948, -39.5587) (-49.8827, -40.0544) (-46.5482, -41.6327) (-43.7358, -39.2451) (-43.801, -38.7494) (-45.8894, -22.8863) (-45.9547, -22.3906) (-49.2892, -20.8123) (-52.1017, -23.1998), closed, covered, Arc from point 3 over 3, Arc from point 8 over 3)
  coordinate_system CS_L1_1Magnet2N3_1 = origin=(-48.017903mm, -31.235601mm, 0mm) x=(-1.0551452mm, -0.1389125mm, 0mm) y=(0.1389125mm, -1.0551452mm, 0mm)
  L1_1Magnet2N3_1 [N30UH_20C [ref. Temp]_2D3DFactMagnet, oriented by CS_L1_1Magnet2N3_1] = polyline(z=0mm, xy in mm: (-49.948, -39.5587) (-43.9993, -38.7755) (-46.0877, -22.9124) (-52.0364, -23.6956) (-49.948, -39.5587), closed, covered)
  Rotor_Pocket_5 [vacuum] = polyline(z=0mm, xy in mm: (-39.5587, 49.948) (-40.0544, 49.8827) (-41.6327, 46.5482) (-39.2451, 43.7358) (-38.7494, 43.801) (-22.8863, 45.8894) (-22.3906, 45.9547) (-20.8123, 49.2892) (-23.1998, 52.1017) (-23.6956, 52.0364) (-39.5587, 49.948), closed, covered, Arc from point 1 over 3, Arc from point 6 over 3)
  coordinate_system CS_L1_1Magnet2N2_1 = origin=(-31.235601mm, 48.017903mm, 0mm) x=(-0.1389125mm, 1.0551452mm, 0mm) y=(-1.0551452mm, -0.1389125mm, 0mm)
  L1_1Magnet2N2_1 [N30UH_20C [ref. Temp]_2D3DFactMagnet, oriented by CS_L1_1Magnet2N2_1] = polyline(z=0mm, xy in mm: (-39.5587, 49.948) (-38.7755, 43.9993) (-22.9124, 46.0877) (-23.6956, 52.0364) (-39.5587, 49.948), closed, covered)
  Rotor_Pocket_6 [vacuum] = polyline(z=0mm, xy in mm: (-20.4366, -53.2462) (-20.0399, -53.5506) (-7.3463, -63.2908) (-6.9496, -63.5952) (-3.4757, -62.3533) (-3.1753, -58.6764) (-3.572, -58.372) (-16.2656, -48.6318) (-16.6623, -48.3274) (-20.1362, -49.5693) (-20.4366, -53.2462), closed, covered, Arc from point 3 over 3, Arc from point 8 over 3)
  coordinate_system CS_L1_1Magnet2S4_1 = origin=(-11.866879mm, -56.04069mm, 0mm) x=(0.64787435mm, 0.84432629mm, 0mm) y=(-0.84432629mm, 0.64787435mm, 0mm)
  L1_1Magnet2S4_1 [N30UH_20C [ref. Temp]_2D3DFactMagnet, oriented by CS_L1_1Magnet2S4_1] = polyline(z=0mm, xy in mm: (-7.3463, -63.2908) (-3.6937, -58.5307) (-16.3874, -48.7905) (-20.0399, -53.5506) (-7.3463, -63.2908), closed, covered)
  Rotor_Pocket_7 [vacuum] = polyline(z=0mm, xy in mm: (3.1753, 58.6764) (3.572, 58.372) (16.2656, 48.6318) (16.6623, 48.3274) (20.1362, 49.5693) (20.4366, 53.2462) (20.0399, 53.5506) (7.3463, 63.2908) (6.9496, 63.5952) (3.4757, 62.3533) (3.1753, 58.6764), closed, covered, Arc from point 3 over 3, Arc from point 8 over 3)
  coordinate_system CS_L1_1Magnet2S2_1 = origin=(11.866879mm, 56.04069mm, 0mm) x=(-0.64787435mm, -0.84432629mm, 0mm) y=(0.84432629mm, -0.64787435mm, 0mm)
  L1_1Magnet2S2_1 [N30UH_20C [ref. Temp]_2D3DFactMagnet, oriented by CS_L1_1Magnet2S2_1] = polyline(z=0mm, xy in mm: (7.3463, 63.2908) (3.6937, 58.5307) (16.3874, 48.7905) (20.0399, 53.5506) (7.3463, 63.2908), closed, covered)
  Rotor_Pocket_8 [vacuum] = polyline(z=0mm, xy in mm: (22.8863, -45.8894) (22.3906, -45.9547) (20.8123, -49.2892) (23.1998, -52.1017) (23.6956, -52.0364) (39.5587, -49.948) (40.0544, -49.8827) (41.6327, -46.5482) (39.2451, -43.7358) (38.7494, -43.801) (22.8863, -45.8894), closed, covered, Arc from point 1 over 3, Arc from point 6 over 3)
  coordinate_system CS_L1_1Magnet2N4_1 = origin=(31.235601mm, -48.017903mm, 0mm) x=(0.1389125mm, -1.0551452mm, 0mm) y=(1.0551452mm, 0.1389125mm, 0mm)
  L1_1Magnet2N4_1 [N30UH_20C [ref. Temp]_2D3DFactMagnet, oriented by CS_L1_1Magnet2N4_1] = polyline(z=0mm, xy in mm: (39.5587, -49.948) (38.7755, -43.9993) (22.9124, -46.0877) (23.6956, -52.0364) (39.5587, -49.948), closed, covered)
  Rotor_Pocket_9 [vacuum] = polyline(z=0mm, xy in mm: (43.7358, 39.2451) (43.801, 38.7494) (45.8894, 22.8863) (45.9547, 22.3906) (49.2892, 20.8123) (52.1017, 23.1998) (52.0364, 23.6956) (49.948, 39.5587) (49.8827, 40.0544) (46.5482, 41.6327) (43.7358, 39.2451), closed, covered, Arc from point 3 over 3, Arc from point 8 over 3)
  coordinate_system CS_L1_1Magnet2N1_1 = origin=(48.017903mm, 31.235601mm, 0mm) x=(1.0551452mm, 0.1389125mm, 0mm) y=(-0.1389125mm, 1.0551452mm, 0mm)
  L1_1Magnet2N1_1 [N30UH_20C [ref. Temp]_2D3DFactMagnet, oriented by CS_L1_1Magnet2N1_1] = polyline(z=0mm, xy in mm: (49.948, 39.5587) (43.9993, 38.7755) (46.0877, 22.9124) (52.0364, 23.6956) (49.948, 39.5587), closed, covered)
  Rotor_Pocket_10 [vacuum] = polyline(z=0mm, xy in mm: (48.6318, -16.2656) (48.3274, -16.6623) (49.5693, -20.1362) (53.2462, -20.4366) (53.5506, -20.0399) (63.2908, -7.3463) (63.5952, -6.9496) (62.3533, -3.4757) (58.6764, -3.1753) (58.372, -3.572) (48.6318, -16.2656), closed, covered, Arc from point 1 over 3, Arc from point 6 over 3)
  coordinate_system CS_L1_1Magnet2S1_1 = origin=(56.04069mm, -11.866879mm, 0mm) x=(-0.84432629mm, 0.64787435mm, 0mm) y=(-0.64787435mm, -0.84432629mm, 0mm)
  L1_1Magnet2S1_1 [N30UH_20C [ref. Temp]_2D3DFactMagnet, oriented by CS_L1_1Magnet2S1_1] = polyline(z=0mm, xy in mm: (63.2908, -7.3463) (58.5307, -3.6937) (48.7905, -16.3874) (53.5506, -20.0399) (63.2908, -7.3463), closed, covered)
  Rotor_Pocket_11 [vacuum] = polyline(z=0mm, xy in mm: (-52.0364, 23.6956) (-52.1017, 23.1998) (-49.2892, 20.8123) (-45.9547, 22.3906) (-45.8894, 22.8863) (-43.801, 38.7494) (-43.7358, 39.2451) (-46.5482, 41.6327) (-49.8827, 40.0544) (-49.948, 39.5587) (-52.0364, 23.6956), closed, covered, Arc from point 1 over 3, Arc from point 6 over 3)
  coordinate_system CS_L1_1Magnet1S3_1 = origin=(-48.017903mm, 31.235601mm, 0mm) x=(1.0551452mm, -0.1389125mm, 0mm) y=(0.1389125mm, 1.0551452mm, 0mm)
  L1_1Magnet1S3_1 [N30UH_20C [ref. Temp]_2D3DFactMagnet, oriented by CS_L1_1Magnet1S3_1] = polyline(z=0mm, xy in mm: (-43.9993, 38.7755) (-49.948, 39.5587) (-52.0364, 23.6956) (-46.0877, 22.9124) (-43.9993, 38.7755), closed, covered)
  Rotor_Pocket_12 [vacuum] = polyline(z=0mm, xy in mm: (-40.0544, -49.8827) (-39.5587, -49.948) (-23.6956, -52.0364) (-23.1998, -52.1017) (-20.8123, -49.2892) (-22.3906, -45.9547) (-22.8863, -45.8894) (-38.7494, -43.801) (-39.2451, -43.7358) (-41.6327, -46.5482) (-40.0544, -49.8827), closed, covered, Arc from point 3 over 3, Arc from point 8 over 3)
  coordinate_system CS_L1_1Magnet1S4_1 = origin=(-31.235601mm, -48.017903mm, 0mm) x=(0.1389125mm, 1.0551452mm, 0mm) y=(-1.0551452mm, 0.1389125mm, 0mm)
  L1_1Magnet1S4_1 [N30UH_20C [ref. Temp]_2D3DFactMagnet, oriented by CS_L1_1Magnet1S4_1] = polyline(z=0mm, xy in mm: (-38.7755, -43.9993) (-39.5587, -49.948) (-23.6956, -52.0364) (-22.9124, -46.0877) (-38.7755, -43.9993), closed, covered)
  Rotor_Pocket_13 [vacuum] = polyline(z=0mm, xy in mm: (-20.0399, 53.5506) (-20.4366, 53.2462) (-20.1362, 49.5693) (-16.6623, 48.3274) (-16.2656, 48.6318) (-3.572, 58.372) (-3.1753, 58.6764) (-3.4757, 62.3533) (-6.9496, 63.5952) (-7.3463, 63.2908) (-20.0399, 53.5506), closed, covered, Arc from point 1 over 3, Arc from point 6 over 3)
  coordinate_system CS_L1_1Magnet1N2_1 = origin=(-11.866879mm, 56.04069mm, 0mm) x=(-0.64787435mm, 0.84432629mm, 0mm) y=(-0.84432629mm, -0.64787435mm, 0mm)
  L1_1Magnet1N2_1 [N30UH_20C [ref. Temp]_2D3DFactMagnet, oriented by CS_L1_1Magnet1N2_1] = polyline(z=0mm, xy in mm: (-3.6937, 58.5307) (-7.3463, 63.2908) (-20.0399, 53.5506) (-16.3874, 48.7905) (-3.6937, 58.5307), closed, covered)
  Rotor_Pocket_14 [vacuum] = polyline(z=0mm, xy in mm: (3.572, -58.372) (3.1753, -58.6764) (3.4757, -62.3533) (6.9496, -63.5952) (7.3463, -63.2908) (20.0399, -53.5506) (20.4366, -53.2462) (20.1362, -49.5693) (16.6623, -48.3274) (16.2656, -48.6318) (3.572, -58.372), closed, covered, Arc from point 1 over 3, Arc from point 6 over 3)
  coordinate_system CS_L1_1Magnet1N4_1 = origin=(11.866879mm, -56.04069mm, 0mm) x=(0.64787435mm, -0.84432629mm, 0mm) y=(0.84432629mm, 0.64787435mm, 0mm)
  L1_1Magnet1N4_1 [N30UH_20C [ref. Temp]_2D3DFactMagnet, oriented by CS_L1_1Magnet1N4_1] = polyline(z=0mm, xy in mm: (3.6937, -58.5307) (7.3463, -63.2908) (20.0399, -53.5506) (16.3874, -48.7905) (3.6937, -58.5307), closed, covered)
  Rotor_Pocket_15 [vacuum] = polyline(z=0mm, xy in mm: (22.3906, 45.9547) (22.8863, 45.8894) (38.7494, 43.801) (39.2451, 43.7358) (41.6327, 46.5482) (40.0544, 49.8827) (39.5587, 49.948) (23.6956, 52.0364) (23.1998, 52.1017) (20.8123, 49.2892) (22.3906, 45.9547), closed, covered, Arc from point 3 over 3, Arc from point 8 over 3)
  coordinate_system CS_L1_1Magnet1S2_1 = origin=(31.235601mm, 48.017903mm, 0mm) x=(-0.1389125mm, -1.0551452mm, 0mm) y=(1.0551452mm, -0.1389125mm, 0mm)
  L1_1Magnet1S2_1 [N30UH_20C [ref. Temp]_2D3DFactMagnet, oriented by CS_L1_1Magnet1S2_1] = polyline(z=0mm, xy in mm: (38.7755, 43.9993) (39.5587, 49.948) (23.6956, 52.0364) (22.9124, 46.0877) (38.7755, 43.9993), closed, covered)
  Rotor_Pocket_16 [vacuum] = polyline(z=0mm, xy in mm: (43.7358, -39.2451) (46.5482, -41.6327) (49.8827, -40.0544) (49.948, -39.5587) (52.0364, -23.6956) (52.1017, -23.1998) (49.2892, -20.8123) (45.9547, -22.3906) (45.8894, -22.8863) (43.801, -38.7494) (43.7358, -39.2451), closed, covered, Arc from point 0 over 3, Arc from point 5 over 3)
  coordinate_system CS_L1_1Magnet1S1_1 = origin=(48.017903mm, -31.235601mm, 0mm) x=(-1.0551452mm, 0.1389125mm, 0mm) y=(-0.1389125mm, -1.0551452mm, 0mm)
  L1_1Magnet1S1_1 [N30UH_20C [ref. Temp]_2D3DFactMagnet, oriented by CS_L1_1Magnet1S1_1] = polyline(z=0mm, xy in mm: (43.9993, -38.7755) (49.948, -39.5587) (52.0364, -23.6956) (46.0877, -22.9124) (43.9993, -38.7755), closed, covered)
  Rotor_Pocket_17 [vacuum] = polyline(z=0mm, xy in mm: (48.3274, 16.6623) (48.6318, 16.2656) (58.372, 3.572) (58.6764, 3.1753) (62.3533, 3.4757) (63.5952, 6.9496) (63.2908, 7.3463) (53.5506, 20.0399) (53.2462, 20.4366) (49.5693, 20.1362) (48.3274, 16.6623), closed, covered, Arc from point 3 over 3, Arc from point 8 over 3)
  coordinate_system CS_L1_1Magnet1N1_1 = origin=(56.04069mm, 11.866879mm, 0mm) x=(0.84432629mm, 0.64787435mm, 0mm) y=(-0.64787435mm, 0.84432629mm, 0mm)
  L1_1Magnet1N1_1 [N30UH_20C [ref. Temp]_2D3DFactMagnet, oriented by CS_L1_1Magnet1N1_1] = polyline(z=0mm, xy in mm: (58.5307, 3.6937) (63.2908, 7.3463) (53.5506, 20.0399) (48.7905, 16.3874) (58.5307, 3.6937), closed, covered)
  Rotor_Pocket_18 [vacuum] = polyline(z=0mm, xy in mm: (-57.1231, -31.0153) (-56.4329, -32.254) (-55.7158, -33.4774) (-55.5647, -31.7578) (-57.1231, -31.0153), closed, covered, Arc from point 0 over 3)
  Rotor_Pocket_19 [vacuum] = polyline(z=0mm, xy in mm: (-33.4774, 55.7158) (-31.7578, 55.5647) (-31.0153, 57.1231) (-32.254, 56.4329) (-33.4774, 55.7158), closed, covered, Arc from point 2 over 3)
  Rotor_Pocket_20 [vacuum] = polyline(z=0mm, xy in mm: (-18.4609, -62.3232) (-17.097, -62.7111) (-15.7249, -63.0692) (-16.8339, -61.7463) (-18.4609, -62.3232), closed, covered, Arc from point 0 over 3)
  Rotor_Pocket_21 [vacuum] = polyline(z=0mm, xy in mm: (15.7249, 63.0692) (16.8339, 61.7463) (18.4609, 62.3232) (17.097, 62.7111) (15.7249, 63.0692), closed, covered, Arc from point 2 over 3)
  Rotor_Pocket_22 [vacuum] = polyline(z=0mm, xy in mm: (31.0153, -57.1231) (32.254, -56.4329) (33.4774, -55.7158) (31.7578, -55.5647) (31.0153, -57.1231), closed, covered, Arc from point 0 over 3)
  Rotor_Pocket_23 [vacuum] = polyline(z=0mm, xy in mm: (55.7158, 33.4774) (55.5647, 31.7578) (57.1231, 31.0153) (56.4329, 32.254) (55.7158, 33.4774), closed, covered, Arc from point 2 over 3)
  Rotor_Pocket_24 [vacuum] = polyline(z=0mm, xy in mm: (63.0692, -15.7249) (61.7463, -16.8339) (62.3232, -18.4609) (62.7111, -17.097) (63.0692, -15.7249), closed, covered, Arc from point 2 over 3)
  Rotor_Pocket_25 [vacuum] = polyline(z=0mm, xy in mm: (-57.1231, 31.0153) (-55.5647, 31.7578) (-55.7158, 33.4774) (-56.4329, 32.254) (-57.1231, 31.0153), closed, covered, Arc from point 2 over 3)
  Rotor_Pocket_26 [vacuum] = polyline(z=0mm, xy in mm: (-33.4774, -55.7158) (-32.254, -56.4329) (-31.0153, -57.1231) (-31.7578, -55.5647) (-33.4774, -55.7158), closed, covered, Arc from point 0 over 3)
  Rotor_Pocket_27 [vacuum] = polyline(z=0mm, xy in mm: (-18.4609, 62.3232) (-16.8339, 61.7463) (-15.7249, 63.0692) (-17.097, 62.7111) (-18.4609, 62.3232), closed, covered, Arc from point 2 over 3)
  Rotor_Pocket_28 [vacuum] = polyline(z=0mm, xy in mm: (15.7249, -63.0692) (17.097, -62.7111) (18.4609, -62.3232) (16.8339, -61.7463) (15.7249, -63.0692), closed, covered, Arc from point 0 over 3)
  Rotor_Pocket_29 [vacuum] = polyline(z=0mm, xy in mm: (31.0153, 57.1231) (31.7578, 55.5647) (33.4774, 55.7158) (32.254, 56.4329) (31.0153, 57.1231), closed, covered, Arc from point 2 over 3)
  Rotor_Pocket_30 [vacuum] = polyline(z=0mm, xy in mm: (55.5647, -31.7578) (55.7158, -33.4774) (56.4329, -32.254) (57.1231, -31.0153) (55.5647, -31.7578), closed, covered, Arc from point 1 over 3)
  Rotor_Pocket_31 [vacuum] = polyline(z=0mm, xy in mm: (61.7463, 16.8339) (63.0692, 15.7249) (62.7111, 17.097) (62.3232, 18.4609) (61.7463, 16.8339), closed, covered, Arc from point 1 over 3)
  Shaft [vacuum] = circle(normal=Z, centre=(0mm, 0mm, 0mm), radius=40mm)
  Ph1_P1_C1_1 [Copper (Pure)_20C [ref. Temp]] = user_primitive(RMxprt/LapCoil.dll, DiaGap=132mm, DiaYoke=DiaStatorYoke, Length=Stator_Lam_Length, Skew=StatorSkewAngle, Slots=SlotNumber_Stator, SlotType=SlotType_Stator, Hs0=Hs0_Stator, Hs1=Hs1_Stator, Hs2=17.541151mm, Bs0=Bs0_Stator, Bs1=4.3148444mm, Bs2=6.61426mm, Rs=Rs_Stator, FilletType=FilletType_Stator, Layers=Layers, CoilPitch=5, EndExt=WdgExt_Avg, SpanExt=SpanExt, BendAngle=0deg, SegAngle=SegAngle_Coil_Armature, LenRegion=Model_Length, InfoCoil=1)
  Ph1_P1_C1_1.rotate(axis=Z, angle=315deg)
  Ph1_P1_C2_1 [Copper (Pure)_20C [ref. Temp]] = user_primitive(RMxprt/LapCoil.dll, DiaGap=132mm, DiaYoke=DiaStatorYoke, Length=Stator_Lam_Length, Skew=StatorSkewAngle, Slots=SlotNumber_Stator, SlotType=SlotType_Stator, Hs0=Hs0_Stator, Hs1=Hs1_Stator, Hs2=17.541151mm, Bs0=Bs0_Stator, Bs1=4.3148444mm, Bs2=6.61426mm, Rs=Rs_Stator, FilletType=FilletType_Stator, Layers=Layers, CoilPitch=5, EndExt=WdgExt_Avg, SpanExt=SpanExt, BendAngle=0deg, SegAngle=SegAngle_Coil_Armature, LenRegion=Model_Length, InfoCoil=1)
  Ph1_P1_C2_1.rotate(axis=Z, angle=270deg)
  Ph1_P1_C3_1 [Copper (Pure)_20C [ref. Temp]] = user_primitive(RMxprt/LapCoil.dll, DiaGap=132mm, DiaYoke=DiaStatorYoke, Length=Stator_Lam_Length, Skew=StatorSkewAngle, Slots=SlotNumber_Stator, SlotType=SlotType_Stator, Hs0=Hs0_Stator, Hs1=Hs1_Stator, Hs2=17.541151mm, Bs0=Bs0_Stator, Bs1=4.3148444mm, Bs2=6.61426mm, Rs=Rs_Stator, FilletType=FilletType_Stator, Layers=Layers, CoilPitch=5, EndExt=WdgExt_Avg, SpanExt=SpanExt, BendAngle=0deg, SegAngle=SegAngle_Coil_Armature, LenRegion=Model_Length, InfoCoil=1)
  Ph1_P1_C3_1.rotate(axis=Z, angle=225deg)
  Ph1_P1_C4_1 [Copper (Pure)_20C [ref. Temp]] = user_primitive(RMxprt/LapCoil.dll, DiaGap=132mm, DiaYoke=DiaStatorYoke, Length=Stator_Lam_Length, Skew=StatorSkewAngle, Slots=SlotNumber_Stator, SlotType=SlotType_Stator, Hs0=Hs0_Stator, Hs1=Hs1_Stator, Hs2=17.541151mm, Bs0=Bs0_Stator, Bs1=4.3148444mm, Bs2=6.61426mm, Rs=Rs_Stator, FilletType=FilletType_Stator, Layers=Layers, CoilPitch=5, EndExt=WdgExt_Avg, SpanExt=SpanExt, BendAngle=0deg, SegAngle=SegAngle_Coil_Armature, LenRegion=Model_Length, InfoCoil=1)
  Ph1_P1_C4_1.rotate(axis=Z, angle=180deg)
  Ph1_P2_C1_1 [Copper (Pure)_20C [ref. Temp]] = user_primitive(RMxprt/LapCoil.dll, DiaGap=132mm, DiaYoke=DiaStatorYoke, Length=Stator_Lam_Length, Skew=StatorSkewAngle, Slots=SlotNumber_Stator, SlotType=SlotType_Stator, Hs0=Hs0_Stator, Hs1=Hs1_Stator, Hs2=17.541151mm, Bs0=Bs0_Stator, Bs1=4.3148444mm, Bs2=6.61426mm, Rs=Rs_Stator, FilletType=FilletType_Stator, Layers=Layers, CoilPitch=5, EndExt=WdgExt_Avg, SpanExt=SpanExt, BendAngle=0deg, SegAngle=SegAngle_Coil_Armature, LenRegion=Model_Length, InfoCoil=1)
  Ph1_P2_C1_1.rotate(axis=Z, angle=135deg)
  Ph1_P2_C2_1 [Copper (Pure)_20C [ref. Temp]] = user_primitive(RMxprt/LapCoil.dll, DiaGap=132mm, DiaYoke=DiaStatorYoke, Length=Stator_Lam_Length, Skew=StatorSkewAngle, Slots=SlotNumber_Stator, SlotType=SlotType_Stator, Hs0=Hs0_Stator, Hs1=Hs1_Stator, Hs2=17.541151mm, Bs0=Bs0_Stator, Bs1=4.3148444mm, Bs2=6.61426mm, Rs=Rs_Stator, FilletType=FilletType_Stator, Layers=Layers, CoilPitch=5, EndExt=WdgExt_Avg, SpanExt=SpanExt, BendAngle=0deg, SegAngle=SegAngle_Coil_Armature, LenRegion=Model_Length, InfoCoil=1)
  Ph1_P2_C2_1.rotate(axis=Z, angle=90deg)
  Ph1_P2_C3_1 [Copper (Pure)_20C [ref. Temp]] = user_primitive(RMxprt/LapCoil.dll, DiaGap=132mm, DiaYoke=DiaStatorYoke, Length=Stator_Lam_Length, Skew=StatorSkewAngle, Slots=SlotNumber_Stator, SlotType=SlotType_Stator, Hs0=Hs0_Stator, Hs1=Hs1_Stator, Hs2=17.541151mm, Bs0=Bs0_Stator, Bs1=4.3148444mm, Bs2=6.61426mm, Rs=Rs_Stator, FilletType=FilletType_Stator, Layers=Layers, CoilPitch=5, EndExt=WdgExt_Avg, SpanExt=SpanExt, BendAngle=0deg, SegAngle=SegAngle_Coil_Armature, LenRegion=Model_Length, InfoCoil=1)
  Ph1_P2_C3_1.rotate(axis=Z, angle=45deg)
  Ph1_P2_C4_1 [Copper (Pure)_20C [ref. Temp]] = user_primitive(RMxprt/LapCoil.dll, DiaGap=132mm, DiaYoke=DiaStatorYoke, Length=Stator_Lam_Length, Skew=StatorSkewAngle, Slots=SlotNumber_Stator, SlotType=SlotType_Stator, Hs0=Hs0_Stator, Hs1=Hs1_Stator, Hs2=17.541151mm, Bs0=Bs0_Stator, Bs1=4.3148444mm, Bs2=6.61426mm, Rs=Rs_Stator, FilletType=FilletType_Stator, Layers=Layers, CoilPitch=5, EndExt=WdgExt_Avg, SpanExt=SpanExt, BendAngle=0deg, SegAngle=SegAngle_Coil_Armature, LenRegion=Model_Length, InfoCoil=1)
  Ph1_P2_C4_1.rotate(axis=Z, angle=0deg)
  Ph2_P1_C1_1 [Copper (Pure)_20C [ref. Temp]] = user_primitive(RMxprt/LapCoil.dll, DiaGap=132mm, DiaYoke=DiaStatorYoke, Length=Stator_Lam_Length, Skew=StatorSkewAngle, Slots=SlotNumber_Stator, SlotType=SlotType_Stator, Hs0=Hs0_Stator, Hs1=Hs1_Stator, Hs2=17.541151mm, Bs0=Bs0_Stator, Bs1=4.3148444mm, Bs2=6.61426mm, Rs=Rs_Stator, FilletType=FilletType_Stator, Layers=Layers, CoilPitch=5, EndExt=WdgExt_Avg, SpanExt=SpanExt, BendAngle=0deg, SegAngle=SegAngle_Coil_Armature, LenRegion=Model_Length, InfoCoil=1)
  Ph2_P1_C1_1.rotate(axis=Z, angle=195deg)
  Ph2_P1_C2_1 [Copper (Pure)_20C [ref. Temp]] = user_primitive(RMxprt/LapCoil.dll, DiaGap=132mm, DiaYoke=DiaStatorYoke, Length=Stator_Lam_Length, Skew=StatorSkewAngle, Slots=SlotNumber_Stator, SlotType=SlotType_Stator, Hs0=Hs0_Stator, Hs1=Hs1_Stator, Hs2=17.541151mm, Bs0=Bs0_Stator, Bs1=4.3148444mm, Bs2=6.61426mm, Rs=Rs_Stator, FilletType=FilletType_Stator, Layers=Layers, CoilPitch=5, EndExt=WdgExt_Avg, SpanExt=SpanExt, BendAngle=0deg, SegAngle=SegAngle_Coil_Armature, LenRegion=Model_Length, InfoCoil=1)
  Ph2_P1_C2_1.rotate(axis=Z, angle=150deg)
  Ph2_P1_C3_1 [Copper (Pure)_20C [ref. Temp]] = user_primitive(RMxprt/LapCoil.dll, DiaGap=132mm, DiaYoke=DiaStatorYoke, Length=Stator_Lam_Length, Skew=StatorSkewAngle, Slots=SlotNumber_Stator, SlotType=SlotType_Stator, Hs0=Hs0_Stator, Hs1=Hs1_Stator, Hs2=17.541151mm, Bs0=Bs0_Stator, Bs1=4.3148444mm, Bs2=6.61426mm, Rs=Rs_Stator, FilletType=FilletType_Stator, Layers=Layers, CoilPitch=5, EndExt=WdgExt_Avg, SpanExt=SpanExt, BendAngle=0deg, SegAngle=SegAngle_Coil_Armature, LenRegion=Model_Length, InfoCoil=1)
  Ph2_P1_C3_1.rotate(axis=Z, angle=105deg)
  Ph2_P1_C4_1 [Copper (Pure)_20C [ref. Temp]] = user_primitive(RMxprt/LapCoil.dll, DiaGap=132mm, DiaYoke=DiaStatorYoke, Length=Stator_Lam_Length, Skew=StatorSkewAngle, Slots=SlotNumber_Stator, SlotType=SlotType_Stator, Hs0=Hs0_Stator, Hs1=Hs1_Stator, Hs2=17.541151mm, Bs0=Bs0_Stator, Bs1=4.3148444mm, Bs2=6.61426mm, Rs=Rs_Stator, FilletType=FilletType_Stator, Layers=Layers, CoilPitch=5, EndExt=WdgExt_Avg, SpanExt=SpanExt, BendAngle=0deg, SegAngle=SegAngle_Coil_Armature, LenRegion=Model_Length, InfoCoil=1)
  Ph2_P1_C4_1.rotate(axis=Z, angle=60deg)
  Ph2_P2_C1_1 [Copper (Pure)_20C [ref. Temp]] = user_primitive(RMxprt/LapCoil.dll, DiaGap=132mm, DiaYoke=DiaStatorYoke, Length=Stator_Lam_Length, Skew=StatorSkewAngle, Slots=SlotNumber_Stator, SlotType=SlotType_Stator, Hs0=Hs0_Stator, Hs1=Hs1_Stator, Hs2=17.541151mm, Bs0=Bs0_Stator, Bs1=4.3148444mm, Bs2=6.61426mm, Rs=Rs_Stator, FilletType=FilletType_Stator, Layers=Layers, CoilPitch=5, EndExt=WdgExt_Avg, SpanExt=SpanExt, BendAngle=0deg, SegAngle=SegAngle_Coil_Armature, LenRegion=Model_Length, InfoCoil=1)
  Ph2_P2_C1_1.rotate(axis=Z, angle=15deg)
  Ph2_P2_C2_1 [Copper (Pure)_20C [ref. Temp]] = user_primitive(RMxprt/LapCoil.dll, DiaGap=132mm, DiaYoke=DiaStatorYoke, Length=Stator_Lam_Length, Skew=StatorSkewAngle, Slots=SlotNumber_Stator, SlotType=SlotType_Stator, Hs0=Hs0_Stator, Hs1=Hs1_Stator, Hs2=17.541151mm, Bs0=Bs0_Stator, Bs1=4.3148444mm, Bs2=6.61426mm, Rs=Rs_Stator, FilletType=FilletType_Stator, Layers=Layers, CoilPitch=5, EndExt=WdgExt_Avg, SpanExt=SpanExt, BendAngle=0deg, SegAngle=SegAngle_Coil_Armature, LenRegion=Model_Length, InfoCoil=1)
  Ph2_P2_C2_1.rotate(axis=Z, angle=330deg)
  Ph2_P2_C3_1 [Copper (Pure)_20C [ref. Temp]] = user_primitive(RMxprt/LapCoil.dll, DiaGap=132mm, DiaYoke=DiaStatorYoke, Length=Stator_Lam_Length, Skew=StatorSkewAngle, Slots=SlotNumber_Stator, SlotType=SlotType_Stator, Hs0=Hs0_Stator, Hs1=Hs1_Stator, Hs2=17.541151mm, Bs0=Bs0_Stator, Bs1=4.3148444mm, Bs2=6.61426mm, Rs=Rs_Stator, FilletType=FilletType_Stator, Layers=Layers, CoilPitch=5, EndExt=WdgExt_Avg, SpanExt=SpanExt, BendAngle=0deg, SegAngle=SegAngle_Coil_Armature, LenRegion=Model_Length, InfoCoil=1)
  Ph2_P2_C3_1.rotate(axis=Z, angle=285deg)
  Ph2_P2_C4_1 [Copper (Pure)_20C [ref. Temp]] = user_primitive(RMxprt/LapCoil.dll, DiaGap=132mm, DiaYoke=DiaStatorYoke, Length=Stator_Lam_Length, Skew=StatorSkewAngle, Slots=SlotNumber_Stator, SlotType=SlotType_Stator, Hs0=Hs0_Stator, Hs1=Hs1_Stator, Hs2=17.541151mm, Bs0=Bs0_Stator, Bs1=4.3148444mm, Bs2=6.61426mm, Rs=Rs_Stator, FilletType=FilletType_Stator, Layers=Layers, CoilPitch=5, EndExt=WdgExt_Avg, SpanExt=SpanExt, BendAngle=0deg, SegAngle=SegAngle_Coil_Armature, LenRegion=Model_Length, InfoCoil=1)
  Ph2_P2_C4_1.rotate(axis=Z, angle=240deg)
  Ph3_P1_C1_1 [Copper (Pure)_20C [ref. Temp]] = user_primitive(RMxprt/LapCoil.dll, DiaGap=132mm, DiaYoke=DiaStatorYoke, Length=Stator_Lam_Length, Skew=StatorSkewAngle, Slots=SlotNumber_Stator, SlotType=SlotType_Stator, Hs0=Hs0_Stator, Hs1=Hs1_Stator, Hs2=17.541151mm, Bs0=Bs0_Stator, Bs1=4.3148444mm, Bs2=6.61426mm, Rs=Rs_Stator, FilletType=FilletType_Stator, Layers=Layers, CoilPitch=5, EndExt=WdgExt_Avg, SpanExt=SpanExt, BendAngle=0deg, SegAngle=SegAngle_Coil_Armature, LenRegion=Model_Length, InfoCoil=1)
  Ph3_P1_C1_1.rotate(axis=Z, angle=75deg)
  Ph3_P1_C2_1 [Copper (Pure)_20C [ref. Temp]] = user_primitive(RMxprt/LapCoil.dll, DiaGap=132mm, DiaYoke=DiaStatorYoke, Length=Stator_Lam_Length, Skew=StatorSkewAngle, Slots=SlotNumber_Stator, SlotType=SlotType_Stator, Hs0=Hs0_Stator, Hs1=Hs1_Stator, Hs2=17.541151mm, Bs0=Bs0_Stator, Bs1=4.3148444mm, Bs2=6.61426mm, Rs=Rs_Stator, FilletType=FilletType_Stator, Layers=Layers, CoilPitch=5, EndExt=WdgExt_Avg, SpanExt=SpanExt, BendAngle=0deg, SegAngle=SegAngle_Coil_Armature, LenRegion=Model_Length, InfoCoil=1)
  Ph3_P1_C2_1.rotate(axis=Z, angle=30deg)
  Ph3_P1_C3_1 [Copper (Pure)_20C [ref. Temp]] = user_primitive(RMxprt/LapCoil.dll, DiaGap=132mm, DiaYoke=DiaStatorYoke, Length=Stator_Lam_Length, Skew=StatorSkewAngle, Slots=SlotNumber_Stator, SlotType=SlotType_Stator, Hs0=Hs0_Stator, Hs1=Hs1_Stator, Hs2=17.541151mm, Bs0=Bs0_Stator, Bs1=4.3148444mm, Bs2=6.61426mm, Rs=Rs_Stator, FilletType=FilletType_Stator, Layers=Layers, CoilPitch=5, EndExt=WdgExt_Avg, SpanExt=SpanExt, BendAngle=0deg, SegAngle=SegAngle_Coil_Armature, LenRegion=Model_Length, InfoCoil=1)
  Ph3_P1_C3_1.rotate(axis=Z, angle=345deg)
  Ph3_P1_C4_1 [Copper (Pure)_20C [ref. Temp]] = user_primitive(RMxprt/LapCoil.dll, DiaGap=132mm, DiaYoke=DiaStatorYoke, Length=Stator_Lam_Length, Skew=StatorSkewAngle, Slots=SlotNumber_Stator, SlotType=SlotType_Stator, Hs0=Hs0_Stator, Hs1=Hs1_Stator, Hs2=17.541151mm, Bs0=Bs0_Stator, Bs1=4.3148444mm, Bs2=6.61426mm, Rs=Rs_Stator, FilletType=FilletType_Stator, Layers=Layers, CoilPitch=5, EndExt=WdgExt_Avg, SpanExt=SpanExt, BendAngle=0deg, SegAngle=SegAngle_Coil_Armature, LenRegion=Model_Length, InfoCoil=1)
  Ph3_P1_C4_1.rotate(axis=Z, angle=300deg)
  Ph3_P2_C1_1 [Copper (Pure)_20C [ref. Temp]] = user_primitive(RMxprt/LapCoil.dll, DiaGap=132mm, DiaYoke=DiaStatorYoke, Length=Stator_Lam_Length, Skew=StatorSkewAngle, Slots=SlotNumber_Stator, SlotType=SlotType_Stator, Hs0=Hs0_Stator, Hs1=Hs1_Stator, Hs2=17.541151mm, Bs0=Bs0_Stator, Bs1=4.3148444mm, Bs2=6.61426mm, Rs=Rs_Stator, FilletType=FilletType_Stator, Layers=Layers, CoilPitch=5, EndExt=WdgExt_Avg, SpanExt=SpanExt, BendAngle=0deg, SegAngle=SegAngle_Coil_Armature, LenRegion=Model_Length, InfoCoil=1)
  Ph3_P2_C1_1.rotate(axis=Z, angle=255deg)
  Ph3_P2_C2_1 [Copper (Pure)_20C [ref. Temp]] = user_primitive(RMxprt/LapCoil.dll, DiaGap=132mm, DiaYoke=DiaStatorYoke, Length=Stator_Lam_Length, Skew=StatorSkewAngle, Slots=SlotNumber_Stator, SlotType=SlotType_Stator, Hs0=Hs0_Stator, Hs1=Hs1_Stator, Hs2=17.541151mm, Bs0=Bs0_Stator, Bs1=4.3148444mm, Bs2=6.61426mm, Rs=Rs_Stator, FilletType=FilletType_Stator, Layers=Layers, CoilPitch=5, EndExt=WdgExt_Avg, SpanExt=SpanExt, BendAngle=0deg, SegAngle=SegAngle_Coil_Armature, LenRegion=Model_Length, InfoCoil=1)
  Ph3_P2_C2_1.rotate(axis=Z, angle=210deg)
  Ph3_P2_C3_1 [Copper (Pure)_20C [ref. Temp]] = user_primitive(RMxprt/LapCoil.dll, DiaGap=132mm, DiaYoke=DiaStatorYoke, Length=Stator_Lam_Length, Skew=StatorSkewAngle, Slots=SlotNumber_Stator, SlotType=SlotType_Stator, Hs0=Hs0_Stator, Hs1=Hs1_Stator, Hs2=17.541151mm, Bs0=Bs0_Stator, Bs1=4.3148444mm, Bs2=6.61426mm, Rs=Rs_Stator, FilletType=FilletType_Stator, Layers=Layers, CoilPitch=5, EndExt=WdgExt_Avg, SpanExt=SpanExt, BendAngle=0deg, SegAngle=SegAngle_Coil_Armature, LenRegion=Model_Length, InfoCoil=1)
  Ph3_P2_C3_1.rotate(axis=Z, angle=165deg)
  Ph3_P2_C4_1 [Copper (Pure)_20C [ref. Temp]] = user_primitive(RMxprt/LapCoil.dll, DiaGap=132mm, DiaYoke=DiaStatorYoke, Length=Stator_Lam_Length, Skew=StatorSkewAngle, Slots=SlotNumber_Stator, SlotType=SlotType_Stator, Hs0=Hs0_Stator, Hs1=Hs1_Stator, Hs2=17.541151mm, Bs0=Bs0_Stator, Bs1=4.3148444mm, Bs2=6.61426mm, Rs=Rs_Stator, FilletType=FilletType_Stator, Layers=Layers, CoilPitch=5, EndExt=WdgExt_Avg, SpanExt=SpanExt, BendAngle=0deg, SegAngle=SegAngle_Coil_Armature, LenRegion=Model_Length, InfoCoil=1)
  Ph3_P2_C4_1.rotate(axis=Z, angle=120deg)
  Ph1_P1_C1_2 [Copper (Pure)_20C [ref. Temp]] = Ph1_P1_C1_1.separate_bodies()
  Ph1_P1_C2_2 [Copper (Pure)_20C [ref. Temp]] = Ph1_P1_C2_1.separate_bodies()
  Ph1_P1_C3_2 [Copper (Pure)_20C [ref. Temp]] = Ph1_P1_C3_1.separate_bodies()
  Ph1_P1_C4_2 [Copper (Pure)_20C [ref. Temp]] = Ph1_P1_C4_1.separate_bodies()
  Ph1_P2_C1_2 [Copper (Pure)_20C [ref. Temp]] = Ph1_P2_C1_1.separate_bodies()
  Ph1_P2_C2_2 [Copper (Pure)_20C [ref. Temp]] = Ph1_P2_C2_1.separate_bodies()
  Ph1_P2_C3_2 [Copper (Pure)_20C [ref. Temp]] = Ph1_P2_C3_1.separate_bodies()
  Ph1_P2_C4_2 [Copper (Pure)_20C [ref. Temp]] = Ph1_P2_C4_1.separate_bodies()
  Ph2_P1_C1_2 [Copper (Pure)_20C [ref. Temp]] = Ph2_P1_C1_1.separate_bodies()
  Ph2_P1_C2_2 [Copper (Pure)_20C [ref. Temp]] = Ph2_P1_C2_1.separate_bodies()
  Ph2_P1_C3_2 [Copper (Pure)_20C [ref. Temp]] = Ph2_P1_C3_1.separate_bodies()
  Ph2_P1_C4_2 [Copper (Pure)_20C [ref. Temp]] = Ph2_P1_C4_1.separate_bodies()
  Ph2_P2_C1_2 [Copper (Pure)_20C [ref. Temp]] = Ph2_P2_C1_1.separate_bodies()
  Ph2_P2_C2_2 [Copper (Pure)_20C [ref. Temp]] = Ph2_P2_C2_1.separate_bodies()
  Ph2_P2_C3_2 [Copper (Pure)_20C [ref. Temp]] = Ph2_P2_C3_1.separate_bodies()
  Ph2_P2_C4_2 [Copper (Pure)_20C [ref. Temp]] = Ph2_P2_C4_1.separate_bodies()
  Ph3_P1_C1_2 [Copper (Pure)_20C [ref. Temp]] = Ph3_P1_C1_1.separate_bodies()
  Ph3_P1_C2_2 [Copper (Pure)_20C [ref. Temp]] = Ph3_P1_C2_1.separate_bodies()
  Ph3_P1_C3_2 [Copper (Pure)_20C [ref. Temp]] = Ph3_P1_C3_1.separate_bodies()
  Ph3_P1_C4_2 [Copper (Pure)_20C [ref. Temp]] = Ph3_P1_C4_1.separate_bodies()
  Ph3_P2_C1_2 [Copper (Pure)_20C [ref. Temp]] = Ph3_P2_C1_1.separate_bodies()
  Ph3_P2_C2_2 [Copper (Pure)_20C [ref. Temp]] = Ph3_P2_C2_1.separate_bodies()
  Ph3_P2_C3_2 [Copper (Pure)_20C [ref. Temp]] = Ph3_P2_C3_1.separate_bodies()
  Ph3_P2_C4_2 [Copper (Pure)_20C [ref. Temp]] = Ph3_P2_C4_1.separate_bodies()
  Rotating_Band [vacuum] = user_primitive(RMxprt/Band.dll, DiaGap=DiaGap - (2 * (Airgap - Banding_Thickness)) + (4 * ((airgap - Banding_Thickness - Sleeve_Thickness) / 4)), DiaYoke=Shaft_Hole_Diameter, Length=0mm, SegAngle=0deg, Fractions=SymmetryFactor, HalfAxial=HalfAxial, InfoCore=0)
  Band_Tool = user_primitive(RMxprt/Band.dll, DiaGap=1mm, DiaYoke=DiaOuter, Length=0mm, SegAngle=SegAngle, Fractions=SymmetryFactor, HalfAxial=HalfAxial, InfoCore=1)
  Whole_Region [vacuum] = user_primitive(RMxprt/Band.dll, DiaGap=DiaGap+Airgap, DiaYoke=DiaOuter, Length=0mm, SegAngle=SegAngle, Fractions=SymmetryFactor, HalfAxial=HalfAxial, InfoCore=100)
  Band_Tool_1 = Band_Tool.copy()
  Stator_Lamination_Primitive.subtract(Band_Tool_1)
  Band_Tool_2 = Band_Tool.copy()
  Rotor_1.subtract(Band_Tool_2)
  Band_Tool_3 = Band_Tool.copy()
  Rotor_Pocket.subtract(Band_Tool_3)
  Band_Tool_4 = Band_Tool.copy()
  L1_1Magnet2S3_1.subtract(Band_Tool_4)
  Band_Tool_5 = Band_Tool.copy()
  Rotor_Pocket_1.subtract(Band_Tool_5)
  Band_Tool_6 = Band_Tool.copy()
  L1_1Magnet1N3_1.subtract(Band_Tool_6)
  Band_Tool_7 = Band_Tool.copy()
  Rotor_Pocket_2.subtract(Band_Tool_7)
  Band_Tool_8 = Band_Tool.copy()
  Rotor_Pocket_3.subtract(Band_Tool_8)
  Band_Tool_9 = Band_Tool.copy()
  Rotor_Pocket_4.subtract(Band_Tool_9)
  Band_Tool_10 = Band_Tool.copy()
  L1_1Magnet2N3_1.subtract(Band_Tool_10)
  Band_Tool_11 = Band_Tool.copy()
  Rotor_Pocket_5.subtract(Band_Tool_11)
  Band_Tool_12 = Band_Tool.copy()
  L1_1Magnet2N2_1.subtract(Band_Tool_12)
  Band_Tool_13 = Band_Tool.copy()
  Rotor_Pocket_6.subtract(Band_Tool_13)
  Band_Tool_14 = Band_Tool.copy()
  L1_1Magnet2S4_1.subtract(Band_Tool_14)
  Band_Tool_15 = Band_Tool.copy()
  Rotor_Pocket_7.subtract(Band_Tool_15)
  Band_Tool_16 = Band_Tool.copy()
  L1_1Magnet2S2_1.subtract(Band_Tool_16)
  Band_Tool_17 = Band_Tool.copy()
  Rotor_Pocket_8.subtract(Band_Tool_17)
  Band_Tool_18 = Band_Tool.copy()
  L1_1Magnet2N4_1.subtract(Band_Tool_18)
  Band_Tool_19 = Band_Tool.copy()
  Rotor_Pocket_9.subtract(Band_Tool_19)
  Band_Tool_20 = Band_Tool.copy()
  L1_1Magnet2N1_1.subtract(Band_Tool_20)
  Band_Tool_21 = Band_Tool.copy()
  Rotor_Pocket_10.subtract(Band_Tool_21)
  Band_Tool_22 = Band_Tool.copy()
  L1_1Magnet2S1_1.subtract(Band_Tool_22)
  Band_Tool_23 = Band_Tool.copy()
  Rotor_Pocket_11.subtract(Band_Tool_23)
  Band_Tool_24 = Band_Tool.copy()
  L1_1Magnet1S3_1.subtract(Band_Tool_24)
  Band_Tool_25 = Band_Tool.copy()
  Rotor_Pocket_12.subtract(Band_Tool_25)
  Band_Tool_26 = Band_Tool.copy()
  L1_1Magnet1S4_1.subtract(Band_Tool_26)
  Band_Tool_27 = Band_Tool.copy()
  Rotor_Pocket_13.subtract(Band_Tool_27)
  Band_Tool_28 = Band_Tool.copy()
  L1_1Magnet1N2_1.subtract(Band_Tool_28)
  Band_Tool_29 = Band_Tool.copy()
  Rotor_Pocket_14.subtract(Band_Tool_29)
  Band_Tool_30 = Band_Tool.copy()
  L1_1Magnet1N4_1.subtract(Band_Tool_30)
  Band_Tool_31 = Band_Tool.copy()
  Rotor_Pocket_15.subtract(Band_Tool_31)
  Band_Tool_32 = Band_Tool.copy()
  L1_1Magnet1S2_1.subtract(Band_Tool_32)
  Band_Tool_33 = Band_Tool.copy()
  Rotor_Pocket_16.subtract(Band_Tool_33)
  Band_Tool_34 = Band_Tool.copy()
  L1_1Magnet1S1_1.subtract(Band_Tool_34)
  Band_Tool_35 = Band_Tool.copy()
  Rotor_Pocket_17.subtract(Band_Tool_35)
  Band_Tool_36 = Band_Tool.copy()
  L1_1Magnet1N1_1.subtract(Band_Tool_36)
  Band_Tool_37 = Band_Tool.copy()
  Rotor_Pocket_18.subtract(Band_Tool_37)
  Band_Tool_38 = Band_Tool.copy()
  Rotor_Pocket_19.subtract(Band_Tool_38)
  Band_Tool_39 = Band_Tool.copy()
  Rotor_Pocket_20.subtract(Band_Tool_39)
  Band_Tool_40 = Band_Tool.copy()
  Rotor_Pocket_21.subtract(Band_Tool_40)
  Band_Tool_41 = Band_Tool.copy()
  Rotor_Pocket_22.subtract(Band_Tool_41)
  Band_Tool_42 = Band_Tool.copy()
  Rotor_Pocket_23.subtract(Band_Tool_42)
  Band_Tool_43 = Band_Tool.copy()
  Rotor_Pocket_24.subtract(Band_Tool_43)
  Band_Tool_44 = Band_Tool.copy()
  Rotor_Pocket_25.subtract(Band_Tool_44)
  Band_Tool_45 = Band_Tool.copy()
  Rotor_Pocket_26.subtract(Band_Tool_45)
  Band_Tool_46 = Band_Tool.copy()
  Rotor_Pocket_27.subtract(Band_Tool_46)
  Band_Tool_47 = Band_Tool.copy()
  Rotor_Pocket_28.subtract(Band_Tool_47)
  Band_Tool_48 = Band_Tool.copy()
  Rotor_Pocket_29.subtract(Band_Tool_48)
  Band_Tool_49 = Band_Tool.copy()
  Rotor_Pocket_30.subtract(Band_Tool_49)
  Band_Tool_50 = Band_Tool.copy()
  Rotor_Pocket_31.subtract(Band_Tool_50)
  Band_Tool_51 = Band_Tool.copy()
  Shaft.subtract(Band_Tool_51)
  Band_Tool_52 = Band_Tool.copy()
  Ph1_P1_C1_1.subtract(Band_Tool_52)
  Band_Tool_53 = Band_Tool.copy()
  Ph1_P1_C2_1.subtract(Band_Tool_53)
  Band_Tool_54 = Band_Tool.copy()
  Ph1_P1_C3_1.subtract(Band_Tool_54)
  Band_Tool_55 = Band_Tool.copy()
  Ph1_P1_C4_1.subtract(Band_Tool_55)
  Band_Tool_56 = Band_Tool.copy()
  Ph1_P2_C1_1.subtract(Band_Tool_56)
  Band_Tool_57 = Band_Tool.copy()
  Ph1_P2_C2_1.subtract(Band_Tool_57)
  Band_Tool_58 = Band_Tool.copy()
  Ph1_P2_C3_1.subtract(Band_Tool_58)
  Band_Tool_59 = Band_Tool.copy()
  Ph1_P2_C4_1.subtract(Band_Tool_59)
  Band_Tool_60 = Band_Tool.copy()
  Ph2_P1_C1_1.subtract(Band_Tool_60)
  Band_Tool_61 = Band_Tool.copy()
  Ph2_P1_C2_1.subtract(Band_Tool_61)
  Band_Tool_62 = Band_Tool.copy()
  Ph2_P1_C3_1.subtract(Band_Tool_62)
  Band_Tool_63 = Band_Tool.copy()
  Ph2_P1_C4_1.subtract(Band_Tool_63)
  Band_Tool_64 = Band_Tool.copy()
  Ph2_P2_C1_1.subtract(Band_Tool_64)
  Band_Tool_65 = Band_Tool.copy()
  Ph2_P2_C2_1.subtract(Band_Tool_65)
  Band_Tool_66 = Band_Tool.copy()
  Ph2_P2_C3_1.subtract(Band_Tool_66)
  Band_Tool_67 = Band_Tool.copy()
  Ph2_P2_C4_1.subtract(Band_Tool_67)
  Band_Tool_68 = Band_Tool.copy()
  Ph3_P1_C1_1.subtract(Band_Tool_68)
  Band_Tool_69 = Band_Tool.copy()
  Ph3_P1_C2_1.subtract(Band_Tool_69)
  Band_Tool_70 = Band_Tool.copy()
  Ph3_P1_C3_1.subtract(Band_Tool_70)
  Band_Tool_71 = Band_Tool.copy()
  Ph3_P1_C4_1.subtract(Band_Tool_71)
  Band_Tool_72 = Band_Tool.copy()
  Ph3_P2_C1_1.subtract(Band_Tool_72)
  Band_Tool_73 = Band_Tool.copy()
  Ph3_P2_C2_1.subtract(Band_Tool_73)
  Band_Tool_74 = Band_Tool.copy()
  Ph3_P2_C3_1.subtract(Band_Tool_74)
  Band_Tool_75 = Band_Tool.copy()
  Ph3_P2_C4_1.subtract(Band_Tool_75)
  Band_Tool_76 = Band_Tool.copy()
  Ph1_P1_C1_2.subtract(Band_Tool_76)
  Band_Tool_77 = Band_Tool.copy()
  Ph1_P1_C2_2.subtract(Band_Tool_77)
  Band_Tool_78 = Band_Tool.copy()
  Ph1_P1_C3_2.subtract(Band_Tool_78)
  Band_Tool_79 = Band_Tool.copy()
  Ph1_P1_C4_2.subtract(Band_Tool_79)
  Band_Tool_80 = Band_Tool.copy()
  Ph1_P2_C1_2.subtract(Band_Tool_80)
  Band_Tool_81 = Band_Tool.copy()
  Ph1_P2_C2_2.subtract(Band_Tool_81)
  Band_Tool_82 = Band_Tool.copy()
  Ph1_P2_C3_2.subtract(Band_Tool_82)
  Band_Tool_83 = Band_Tool.copy()
  Ph1_P2_C4_2.subtract(Band_Tool_83)
  Band_Tool_84 = Band_Tool.copy()
  Ph2_P1_C1_2.subtract(Band_Tool_84)
  Band_Tool_85 = Band_Tool.copy()
  Ph2_P1_C2_2.subtract(Band_Tool_85)
  Band_Tool_86 = Band_Tool.copy()
  Ph2_P1_C3_2.subtract(Band_Tool_86)
  Band_Tool_87 = Band_Tool.copy()
  Ph2_P1_C4_2.subtract(Band_Tool_87)
  Band_Tool_88 = Band_Tool.copy()
  Ph2_P2_C1_2.subtract(Band_Tool_88)
  Band_Tool_89 = Band_Tool.copy()
  Ph2_P2_C2_2.subtract(Band_Tool_89)
  Band_Tool_90 = Band_Tool.copy()
  Ph2_P2_C3_2.subtract(Band_Tool_90)
  Band_Tool_91 = Band_Tool.copy()
  Ph2_P2_C4_2.subtract(Band_Tool_91)
  Band_Tool_92 = Band_Tool.copy()
  Ph3_P1_C1_2.subtract(Band_Tool_92)
  Band_Tool_93 = Band_Tool.copy()
  Ph3_P1_C2_2.subtract(Band_Tool_93)
  Band_Tool_94 = Band_Tool.copy()
  Ph3_P1_C3_2.subtract(Band_Tool_94)
  Band_Tool_95 = Band_Tool.copy()
  Ph3_P1_C4_2.subtract(Band_Tool_95)
  Band_Tool_96 = Band_Tool.copy()
  Ph3_P2_C1_2.subtract(Band_Tool_96)
  Band_Tool_97 = Band_Tool.copy()
  Ph3_P2_C2_2.subtract(Band_Tool_97)
  Band_Tool_98 = Band_Tool.copy()
  Ph3_P2_C3_2.subtract(Band_Tool_98)
  Band_Tool_99 = Band_Tool.copy()
  Ph3_P2_C4_2.subtract(Band_Tool_99)
  Rotating_Band.subtract(Band_Tool)
motion:
  MotionSetup1: Band Move_Type=Rotate Coordinate_System=Global Axis=Z Is_Positive=true InitPos=InitialPositionMD Angular_Velocity=-MachineRPM Objects=Rotating_Band
  Moving1: Moving Objects=[Rotor_1, Rotor_Pocket, L1_1Magnet2S3_1, Rotor_Pocket_1, L1_1Magnet1N3_1, Rotor_Pocket_2, Rotor_Pocket_3, Rotor_Pocket_4, L1_1Magnet2N3_1, Rotor_Pocket_5, L1_1Magnet2N2_1, Rotor_Pocket_6, L1_1Magnet2S4_1, Rotor_Pocket_7, L1_1Magnet2S2_1, Rotor_Pocket_8, L1_1Magnet2N4_1, Rotor_Pocket_9, L1_1Magnet2N1_1, Rotor_Pocket_10, L1_1Magnet2S1_1, Rotor_Pocket_11, L1_1Magnet1S3_1, Rotor_Pocket_12, L1_1Magnet1S4_1, Rotor_Pocket_13, L1_1Magnet1N2_1, Rotor_Pocket_14, L1_1Magnet1N4_1, Rotor_Pocket_15, L1_1Magnet1S2_1, Rotor_Pocket_16, L1_1Magnet1S1_1, Rotor_Pocket_17, L1_1Magnet1N1_1, Rotor_Pocket_18..Rotor_Pocket_31, Shaft]
boundaries and excitations:
  VectorPotential1: Vector Potential Edges=Whole_Region.edge(at (0, -99, 0)) Value=0
  CT_Ph1_P1_C1_Ret: Coil Objects=Ph1_P1_C1_1 Conductor_number=6 Winding=WG_Ph1_P1 PolarityType=Negative
  CT_Ph1_P1_C1_Go: Coil Objects=Ph1_P1_C1_2 Conductor_number=6 Winding=WG_Ph1_P1 PolarityType=Positive
  CT_Ph1_P1_C2_Go: Coil Objects=Ph1_P1_C2_1 Conductor_number=6 Winding=WG_Ph1_P1 PolarityType=Positive
  CT_Ph1_P1_C2_Ret: Coil Objects=Ph1_P1_C2_2 Conductor_number=6 Winding=WG_Ph1_P1 PolarityType=Negative
  CT_Ph1_P1_C3_Ret: Coil Objects=Ph1_P1_C3_1 Conductor_number=6 Winding=WG_Ph1_P1 PolarityType=Negative
  CT_Ph1_P1_C3_Go: Coil Objects=Ph1_P1_C3_2 Conductor_number=6 Winding=WG_Ph1_P1 PolarityType=Positive
  CT_Ph1_P1_C4_Go: Coil Objects=Ph1_P1_C4_1 Conductor_number=6 Winding=WG_Ph1_P1 PolarityType=Positive
  CT_Ph1_P1_C4_Ret: Coil Objects=Ph1_P1_C4_2 Conductor_number=6 Winding=WG_Ph1_P1 PolarityType=Negative
  CT_Ph1_P2_C1_Ret: Coil Objects=Ph1_P2_C1_1 Conductor_number=6 Winding=WG_Ph1_P1 PolarityType=Negative
  CT_Ph1_P2_C1_Go: Coil Objects=Ph1_P2_C1_2 Conductor_number=6 Winding=WG_Ph1_P1 PolarityType=Positive
  CT_Ph1_P2_C2_Go: Coil Objects=Ph1_P2_C2_1 Conductor_number=6 Winding=WG_Ph1_P1 PolarityType=Positive
  CT_Ph1_P2_C2_Ret: Coil Objects=Ph1_P2_C2_2 Conductor_number=6 Winding=WG_Ph1_P1 PolarityType=Negative
  CT_Ph1_P2_C3_Ret: Coil Objects=Ph1_P2_C3_1 Conductor_number=6 Winding=WG_Ph1_P1 PolarityType=Negative
  CT_Ph1_P2_C3_Go: Coil Objects=Ph1_P2_C3_2 Conductor_number=6 Winding=WG_Ph1_P1 PolarityType=Positive
  CT_Ph1_P2_C4_Go: Coil Objects=Ph1_P2_C4_1 Conductor_number=6 Winding=WG_Ph1_P1 PolarityType=Positive
  CT_Ph1_P2_C4_Ret: Coil Objects=Ph1_P2_C4_2 Conductor_number=6 Winding=WG_Ph1_P1 PolarityType=Negative
  CT_Ph2_P1_C1_Ret: Coil Objects=Ph2_P1_C1_1 Conductor_number=6 Winding=WG_Ph2_P1 PolarityType=Negative
  CT_Ph2_P1_C1_Go: Coil Objects=Ph2_P1_C1_2 Conductor_number=6 Winding=WG_Ph2_P1 PolarityType=Positive
  CT_Ph2_P1_C2_Go: Coil Objects=Ph2_P1_C2_1 Conductor_number=6 Winding=WG_Ph2_P1 PolarityType=Positive
  CT_Ph2_P1_C2_Ret: Coil Objects=Ph2_P1_C2_2 Conductor_number=6 Winding=WG_Ph2_P1 PolarityType=Negative
  CT_Ph2_P1_C3_Ret: Coil Objects=Ph2_P1_C3_1 Conductor_number=6 Winding=WG_Ph2_P1 PolarityType=Negative
  CT_Ph2_P1_C3_Go: Coil Objects=Ph2_P1_C3_2 Conductor_number=6 Winding=WG_Ph2_P1 PolarityType=Positive
  CT_Ph2_P1_C4_Go: Coil Objects=Ph2_P1_C4_1 Conductor_number=6 Winding=WG_Ph2_P1 PolarityType=Positive
  CT_Ph2_P1_C4_Ret: Coil Objects=Ph2_P1_C4_2 Conductor_number=6 Winding=WG_Ph2_P1 PolarityType=Negative
  CT_Ph2_P2_C1_Ret: Coil Objects=Ph2_P2_C1_1 Conductor_number=6 Winding=WG_Ph2_P1 PolarityType=Negative
  CT_Ph2_P2_C1_Go: Coil Objects=Ph2_P2_C1_2 Conductor_number=6 Winding=WG_Ph2_P1 PolarityType=Positive
  CT_Ph2_P2_C2_Go: Coil Objects=Ph2_P2_C2_1 Conductor_number=6 Winding=WG_Ph2_P1 PolarityType=Positive
  CT_Ph2_P2_C2_Ret: Coil Objects=Ph2_P2_C2_2 Conductor_number=6 Winding=WG_Ph2_P1 PolarityType=Negative
  CT_Ph2_P2_C3_Ret: Coil Objects=Ph2_P2_C3_1 Conductor_number=6 Winding=WG_Ph2_P1 PolarityType=Negative
  CT_Ph2_P2_C3_Go: Coil Objects=Ph2_P2_C3_2 Conductor_number=6 Winding=WG_Ph2_P1 PolarityType=Positive
  CT_Ph2_P2_C4_Go: Coil Objects=Ph2_P2_C4_1 Conductor_number=6 Winding=WG_Ph2_P1 PolarityType=Positive
  CT_Ph2_P2_C4_Ret: Coil Objects=Ph2_P2_C4_2 Conductor_number=6 Winding=WG_Ph2_P1 PolarityType=Negative
  CT_Ph3_P1_C1_Ret: Coil Objects=Ph3_P1_C1_1 Conductor_number=6 Winding=WG_Ph3_P1 PolarityType=Negative
  CT_Ph3_P1_C1_Go: Coil Objects=Ph3_P1_C1_2 Conductor_number=6 Winding=WG_Ph3_P1 PolarityType=Positive
  CT_Ph3_P1_C2_Go: Coil Objects=Ph3_P1_C2_1 Conductor_number=6 Winding=WG_Ph3_P1 PolarityType=Positive
  CT_Ph3_P1_C2_Ret: Coil Objects=Ph3_P1_C2_2 Conductor_number=6 Winding=WG_Ph3_P1 PolarityType=Negative
  CT_Ph3_P1_C3_Ret: Coil Objects=Ph3_P1_C3_1 Conductor_number=6 Winding=WG_Ph3_P1 PolarityType=Negative
  CT_Ph3_P1_C3_Go: Coil Objects=Ph3_P1_C3_2 Conductor_number=6 Winding=WG_Ph3_P1 PolarityType=Positive
  CT_Ph3_P1_C4_Go: Coil Objects=Ph3_P1_C4_1 Conductor_number=6 Winding=WG_Ph3_P1 PolarityType=Positive
  CT_Ph3_P1_C4_Ret: Coil Objects=Ph3_P1_C4_2 Conductor_number=6 Winding=WG_Ph3_P1 PolarityType=Negative
  CT_Ph3_P2_C1_Ret: Coil Objects=Ph3_P2_C1_1 Conductor_number=6 Winding=WG_Ph3_P1 PolarityType=Negative
  CT_Ph3_P2_C1_Go: Coil Objects=Ph3_P2_C1_2 Conductor_number=6 Winding=WG_Ph3_P1 PolarityType=Positive
  CT_Ph3_P2_C2_Go: Coil Objects=Ph3_P2_C2_1 Conductor_number=6 Winding=WG_Ph3_P1 PolarityType=Positive
  CT_Ph3_P2_C2_Ret: Coil Objects=Ph3_P2_C2_2 Conductor_number=6 Winding=WG_Ph3_P1 PolarityType=Negative
  CT_Ph3_P2_C3_Ret: Coil Objects=Ph3_P2_C3_1 Conductor_number=6 Winding=WG_Ph3_P1 PolarityType=Negative
  CT_Ph3_P2_C3_Go: Coil Objects=Ph3_P2_C3_2 Conductor_number=6 Winding=WG_Ph3_P1 PolarityType=Positive
  CT_Ph3_P2_C4_Go: Coil Objects=Ph3_P2_C4_1 Conductor_number=6 Winding=WG_Ph3_P1 PolarityType=Positive
  CT_Ph3_P2_C4_Ret: Coil Objects=Ph3_P2_C4_2 Conductor_number=6 Winding=WG_Ph3_P1 PolarityType=Negative
  L1_1Magnet2S3_1: Current Objects=L1_1Magnet2S3_1 Current=0A IsSolid=true IsPositive=true
  L1_1Magnet2N3_1: Current Objects=L1_1Magnet2N3_1 Current=0A IsSolid=true IsPositive=true
  L1_1Magnet2N2_1: Current Objects=L1_1Magnet2N2_1 Current=0A IsSolid=true IsPositive=true
  L1_1Magnet2S4_1: Current Objects=L1_1Magnet2S4_1 Current=0A IsSolid=true IsPositive=true
  L1_1Magnet2S2_1: Current Objects=L1_1Magnet2S2_1 Current=0A IsSolid=true IsPositive=true
  L1_1Magnet2N4_1: Current Objects=L1_1Magnet2N4_1 Current=0A IsSolid=true IsPositive=true
  L1_1Magnet2N1_1: Current Objects=L1_1Magnet2N1_1 Current=0A IsSolid=true IsPositive=true
  L1_1Magnet2S1_1: Current Objects=L1_1Magnet2S1_1 Current=0A IsSolid=true IsPositive=true
  L1_1Magnet1N3_1: Current Objects=L1_1Magnet1N3_1 Current=0A IsSolid=true IsPositive=true
  L1_1Magnet1S3_1: Current Objects=L1_1Magnet1S3_1 Current=0A IsSolid=true IsPositive=true
  L1_1Magnet1S4_1: Current Objects=L1_1Magnet1S4_1 Current=0A IsSolid=true IsPositive=true
  L1_1Magnet1N2_1: Current Objects=L1_1Magnet1N2_1 Current=0A IsSolid=true IsPositive=true
  L1_1Magnet1N4_1: Current Objects=L1_1Magnet1N4_1 Current=0A IsSolid=true IsPositive=true
  L1_1Magnet1S2_1: Current Objects=L1_1Magnet1S2_1 Current=0A IsSolid=true IsPositive=true
  L1_1Magnet1S1_1: Current Objects=L1_1Magnet1S1_1 Current=0A IsSolid=true IsPositive=true
  L1_1Magnet1N1_1: Current Objects=L1_1Magnet1N1_1 Current=0A IsSolid=true IsPositive=true
  WG_Ph1_P1: Winding Group Type=Current IsSolid=false Current="IPeak * sin((pi * MachineRPM/1rpm*NumPoles / 60*time + (360 - 0) / 360 * 2 * pi) + PhaseAdvance )" ParallelBranchesNum=ParallelPaths
  WG_Ph2_P1: Winding Group Type=Current IsSolid=false Current="IPeak * sin((pi * MachineRPM/1rpm*NumPoles / 60*time + (360 - 120) / 360 * 2 * pi) + PhaseAdvance )" ParallelBranchesNum=ParallelPaths
  WG_Ph3_P1: Winding Group Type=Current IsSolid=false Current="IPeak * sin((pi * MachineRPM/1rpm*NumPoles / 60*time + (360 - 240) / 360 * 2 * pi) + PhaseAdvance )" ParallelBranchesNum=ParallelPaths
  eddy effects on: L1_1Magnet2S3_1, L1_1Magnet1N3_1, L1_1Magnet2N3_1, L1_1Magnet2N2_1, L1_1Magnet2S4_1, L1_1Magnet2S2_1, L1_1Magnet2N4_1, L1_1Magnet2N1_1, L1_1Magnet2S1_1, L1_1Magnet1S3_1, L1_1Magnet1S4_1, L1_1Magnet1N2_1, L1_1Magnet1N4_1, L1_1Magnet1S2_1, L1_1Magnet1S1_1, L1_1Magnet1N1_1
  core loss on: Stator_Lamination_Primitive, Rotor_1
mesh:
  CylindricalGap1: CylindricalGap Objects=Rotating_Band BandMappingAngle="(360/720) deg" Objects=Rotating_Band
temperatures:
  Stator_Lamination_Primitive, Rotor_1, Rotor_Pocket, Rotor_Pocket_1..Rotor_Pocket_31, Shaft, Ph1_P1_C1_1, Ph1_P1_C2_1, Ph1_P1_C3_1, Ph1_P1_C4_1, Ph1_P2_C1_1, Ph1_P2_C2_1, Ph1_P2_C3_1, Ph1_P2_C4_1, Ph2_P1_C1_1, Ph2_P1_C2_1, Ph2_P1_C3_1, Ph2_P1_C4_1, Ph2_P2_C1_1, Ph2_P2_C2_1, Ph2_P2_C3_1, Ph2_P2_C4_1, Ph3_P1_C1_1, Ph3_P1_C2_1, Ph3_P1_C3_1, Ph3_P1_C4_1, Ph3_P2_C1_1, Ph3_P2_C2_1, Ph3_P2_C3_1, Ph3_P2_C4_1, Ph1_P1_C1_2, Ph1_P1_C2_2, Ph1_P1_C3_2, Ph1_P1_C4_2, Ph1_P2_C1_2, Ph1_P2_C2_2, Ph1_P2_C3_2, Ph1_P2_C4_2, Ph2_P1_C1_2, Ph2_P1_C2_2, Ph2_P1_C3_2, Ph2_P1_C4_2, Ph2_P2_C1_2, Ph2_P2_C2_2, Ph2_P2_C3_2, Ph2_P2_C4_2, Ph3_P1_C1_2, Ph3_P1_C2_2, Ph3_P1_C3_2, Ph3_P1_C4_2, Ph3_P2_C1_2, Ph3_P2_C2_2, Ph3_P2_C3_2, Ph3_P2_C4_2, Rotating_Band, Whole_Region: 22cel
  L1_1Magnet2S3_1, L1_1Magnet1N3_1, L1_1Magnet2N3_1, L1_1Magnet2N2_1, L1_1Magnet2S4_1, L1_1Magnet2S2_1, L1_1Magnet2N4_1, L1_1Magnet2N1_1, L1_1Magnet2S1_1, L1_1Magnet1S3_1, L1_1Magnet1S4_1, L1_1Magnet1N2_1, L1_1Magnet1N4_1, L1_1Magnet1S2_1, L1_1Magnet1S1_1, L1_1Magnet1N1_1: 65cel
setups:
  Setup1: Transient NonlinearSolverResidual=0.0001 ScalarPotential="Second Order" StopTime="NumTorqueCycles*120/(MachineRPM/1rpm*NumPoles) s" TimeStep="120/(MachineRPM/1rpm*NumPoles)/NumTorquePointsPerCycle s" OutputPerObjectCoreLoss OutputPerObjectSolidLoss InitialTimeStep="120/(MachineRPM/1rpm*NumPoles)/NumTorquePointsPerCycle s" MinTimeStep=0.001s MaxTimeStep=0.003s TimeStepErrTolerance=0.0001
  Setup2: Transient NonlinearSolverResidual=0.0001 ScalarPotential="Second Order" StopTime=25ms TimeStep=12.5us InitialTimeStep=0.002s MinTimeStep=0.001s MaxTimeStep=0.003s TimeStepErrTolerance=0.0001
output variables:
  ThetaED = ((pi * MachineRPM/1rpm*NumPoles / 60*time + (360 - 0) / 360 * 2 * pi)) + pi
  Id_peak = 2/3*(InputCurrent(WG_Ph1_P1)*cos(ThetaED + 360deg)+InputCurrent(WG_Ph2_P1)*cos(ThetaED + 240deg)+InputCurrent(WG_Ph3_P1)*cos(ThetaED + 120deg))
  Iq_peak = 2/3*(InputCurrent(WG_Ph1_P1)*-sin(ThetaED + 360deg)+InputCurrent(WG_Ph2_P1)*-sin(ThetaED + 240deg)+InputCurrent(WG_Ph3_P1)*-sin(ThetaED + 120deg))
  PsiD = 2/3*(FluxLinkage(WG_Ph1_P1)*cos(ThetaED + 360deg)+FluxLinkage(WG_Ph2_P1)*cos(ThetaED + 240deg)+FluxLinkage(WG_Ph3_P1)*cos(ThetaED + 120deg))
  PsiQ = 2/3*(FluxLinkage(WG_Ph1_P1)*-sin(ThetaED + 360deg)+FluxLinkage(WG_Ph2_P1)*-sin(ThetaED + 240deg)+FluxLinkage(WG_Ph3_P1)*-sin(ThetaED + 120deg))
  TorqueDQ = 3/2*NumPoles/2*(PsiD*Iq_peak - PsiQ*Id_peak)
reports:
  Induced Voltage Plots: InducedVoltage(WG_Ph1_P1), InducedVoltage(WG_Ph2_P1), InducedVoltage(WG_Ph3_P1) vs Time on Setup1 : Transient
  Drive Current Plots: InputCurrent(WG_Ph1_P1), InputCurrent(WG_Ph2_P1), InputCurrent(WG_Ph3_P1), Id_peak, Iq_peak vs Time on Setup1 : Transient
  Flux Linkage Plots: FluxLinkage(WG_Ph1_P1), FluxLinkage(WG_Ph2_P1), FluxLinkage(WG_Ph3_P1), PsiD, PsiQ vs Time on Setup1 : Transient
  Torque Plots: -Moving1.Torque, TorqueDQ vs Time on Setup1 : Transient
  setup2_InducedVoltage: InducedVoltage(WG_Ph1_P1), InducedVoltage(WG_Ph2_P1), InducedVoltage(WG_Ph3_P1) vs Time on Setup2 : Transient
  Winding Plot3: InputCurrent(WG_Ph1_P1), InputCurrent(WG_Ph2_P1), InputCurrent(WG_Ph3_P1) vs Time on Setup2 : Transient
